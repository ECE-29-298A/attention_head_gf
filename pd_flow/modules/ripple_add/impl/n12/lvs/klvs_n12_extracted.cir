* Extracted by KLayout with GF180MCU LVS runset on : 26/11/2026 04:59

.SUBCKT ripple_add VGND VPWR VSUB a[0] a[10] a[11] a[1] a[2] a[3] a[4] a[5]
+ a[6] a[7] a[8] a[9] b[0] b[10] b[11] b[1] b[2] b[3] b[4] b[5] b[6] b[7] b[8]
+ b[9] cin s[0] s[10] s[11] s[1] s[2] s[3] s[4] s[5] s[6] s[7] s[8] s[9]
X$1 VGND a[0] s[0] b[0] \$8 cin VPWR VPWR VSUB gf180mcu_fd_sc_mcu7t5v0__addf_1
X$3 VGND VPWR VPWR VSUB gf180mcu_fd_sc_mcu7t5v0__fillcap_8
X$4 VGND b[11] \$82 s[11] a[11] VPWR VPWR VSUB gf180mcu_fd_sc_mcu7t5v0__xor3_1
X$5 VGND a[1] s[1] b[1] \$18 \$8 VPWR VPWR VSUB gf180mcu_fd_sc_mcu7t5v0__addf_1
X$6 VGND a[3] s[3] b[3] \$33 \$23 VPWR VPWR VSUB gf180mcu_fd_sc_mcu7t5v0__addf_1
X$7 VGND a[7] s[7] b[7] \$60 \$53 VPWR VPWR VSUB gf180mcu_fd_sc_mcu7t5v0__addf_1
X$8 VGND a[9] s[9] b[9] \$78 \$68 VPWR VPWR VSUB gf180mcu_fd_sc_mcu7t5v0__addf_1
X$9 VGND a[5] s[5] b[5] \$48 \$38 VPWR VPWR VSUB gf180mcu_fd_sc_mcu7t5v0__addf_1
X$10 VGND a[8] s[8] b[8] \$68 \$60 VPWR VPWR VSUB
+ gf180mcu_fd_sc_mcu7t5v0__addf_1
X$11 VGND a[10] s[10] b[10] \$82 \$78 VPWR VPWR VSUB
+ gf180mcu_fd_sc_mcu7t5v0__addf_1
X$12 VGND a[6] s[6] b[6] \$53 \$48 VPWR VPWR VSUB
+ gf180mcu_fd_sc_mcu7t5v0__addf_1
X$13 VGND a[2] s[2] b[2] \$23 \$18 VPWR VPWR VSUB
+ gf180mcu_fd_sc_mcu7t5v0__addf_1
X$14 VGND a[4] s[4] b[4] \$38 \$33 VPWR VPWR VSUB
+ gf180mcu_fd_sc_mcu7t5v0__addf_1
.ENDS ripple_add

.SUBCKT gf180mcu_fd_sc_mcu7t5v0__xor3_1 VSS A1 A3 Z A2 VDD \$21 VSUB
M$1 \$19 \$4 \$5 \$21 pfet_05v0 L=0.5U W=0.565U AS=0.2486P AD=0.0904P PS=2.01U
+ PD=0.885U
M$2 VDD A3 \$19 \$21 pfet_05v0 L=0.5U W=0.565U AS=0.0904P AD=0.35315P PS=0.885U
+ PD=1.96U
M$3 \$16 \$5 VDD \$21 pfet_05v0 L=0.5U W=1.22U AS=0.35315P AD=0.3172P PS=1.96U
+ PD=1.74U
M$4 Z A3 \$16 \$21 pfet_05v0 L=0.5U W=1.22U AS=0.3172P AD=0.3172P PS=1.74U
+ PD=1.74U
M$5 \$16 \$4 Z \$21 pfet_05v0 L=0.5U W=1.22U AS=0.3172P AD=0.5368P PS=1.74U
+ PD=3.32U
M$6 \$17 A2 \$2 \$21 pfet_05v0 L=0.5U W=0.36U AS=0.1584P AD=0.0936P PS=1.6U
+ PD=0.88U
M$7 VDD A1 \$17 \$21 pfet_05v0 L=0.5U W=0.36U AS=0.0936P AD=0.194P PS=0.88U
+ PD=1.415U
M$8 \$15 \$2 VDD \$21 pfet_05v0 L=0.5U W=0.565U AS=0.194P AD=0.161025P
+ PS=1.415U PD=1.135U
M$9 \$4 A1 \$15 \$21 pfet_05v0 L=0.5U W=0.565U AS=0.161025P AD=0.1469P
+ PS=1.135U PD=1.085U
M$10 \$15 A2 \$4 \$21 pfet_05v0 L=0.5U W=0.565U AS=0.1469P AD=0.2486P PS=1.085U
+ PD=2.01U
M$11 \$5 \$4 VSS VSUB nfet_05v0 L=0.6U W=0.36U AS=0.1584P AD=0.0936P PS=1.6U
+ PD=0.88U
M$12 \$5 A3 VSS VSUB nfet_05v0 L=0.6U W=0.36U AS=0.218P AD=0.0936P PS=1.52U
+ PD=0.88U
M$13 Z \$5 VSS VSUB nfet_05v0 L=0.6U W=0.82U AS=0.218P AD=0.2132P PS=1.52U
+ PD=1.34U
M$14 \$8 A3 Z VSUB nfet_05v0 L=0.6U W=0.82U AS=0.2132P AD=0.1312P PS=1.34U
+ PD=1.14U
M$15 VSS \$4 \$8 VSUB nfet_05v0 L=0.6U W=0.82U AS=0.1312P AD=0.3608P PS=1.14U
+ PD=2.52U
M$16 \$2 A2 VSS VSUB nfet_05v0 L=0.6U W=0.36U AS=0.1584P AD=0.0936P PS=1.6U
+ PD=0.88U
M$17 VSS A1 \$2 VSUB nfet_05v0 L=0.6U W=0.36U AS=0.0936P AD=0.126P PS=0.88U
+ PD=1.06U
M$18 \$4 \$2 VSS VSUB nfet_05v0 L=0.6U W=0.36U AS=0.126P AD=0.0936P PS=1.06U
+ PD=0.88U
M$19 \$10 A1 \$4 VSUB nfet_05v0 L=0.6U W=0.36U AS=0.0936P AD=0.0576P PS=0.88U
+ PD=0.68U
M$20 VSS A2 \$10 VSUB nfet_05v0 L=0.6U W=0.36U AS=0.0576P AD=0.1584P PS=0.68U
+ PD=1.6U
.ENDS gf180mcu_fd_sc_mcu7t5v0__xor3_1

.SUBCKT gf180mcu_fd_sc_mcu7t5v0__fillcap_8 VSS VDD \$12 VSUB
M$1 VDD \$3 \$2 \$12 pfet_05v0 L=1U W=1.22U AS=0.5368P AD=0.5368P PS=3.32U
+ PD=3.32U
M$2 VDD \$6 \$5 \$12 pfet_05v0 L=1U W=1.22U AS=0.5368P AD=0.5368P PS=3.32U
+ PD=3.32U
M$3 \$6 \$5 VSS VSUB nfet_05v0 L=1U W=0.82U AS=0.3608P AD=0.3608P PS=2.52U
+ PD=2.52U
M$4 \$3 \$2 VSS VSUB nfet_05v0 L=1U W=0.82U AS=0.3608P AD=0.3608P PS=2.52U
+ PD=2.52U
.ENDS gf180mcu_fd_sc_mcu7t5v0__fillcap_8

.SUBCKT gf180mcu_fd_sc_mcu7t5v0__addf_1 VSS A S B CO CI VDD \$26 VSUB
M$1 VDD B \$19 \$26 pfet_05v0 L=0.5U W=0.7U AS=0.308P AD=0.3792P PS=2.28U
+ PD=1.9U
M$2 \$19 A VDD \$26 pfet_05v0 L=0.5U W=0.7U AS=0.3792P AD=0.371P PS=1.9U
+ PD=1.76U
M$3 \$8 CI \$19 \$26 pfet_05v0 L=0.5U W=0.7U AS=0.371P AD=0.217P PS=1.76U
+ PD=1.32U
M$4 \$23 B \$8 \$26 pfet_05v0 L=0.5U W=0.7U AS=0.217P AD=0.119P PS=1.32U
+ PD=1.04U
M$5 VDD A \$23 \$26 pfet_05v0 L=0.5U W=0.7U AS=0.119P AD=0.4073P PS=1.04U
+ PD=2.055U
M$6 CO \$8 VDD \$26 pfet_05v0 L=0.5U W=1.215U AS=0.4073P AD=0.5346P PS=2.055U
+ PD=3.31U
M$7 \$20 A VDD \$26 pfet_05v0 L=0.5U W=0.66U AS=0.3969P AD=0.1122P PS=2.055U
+ PD=1U
M$8 \$21 B \$20 \$26 pfet_05v0 L=0.5U W=0.66U AS=0.1122P AD=0.1122P PS=1U PD=1U
M$9 \$4 CI \$21 \$26 pfet_05v0 L=0.5U W=0.66U AS=0.1122P AD=0.2046P PS=1U
+ PD=1.28U
M$10 \$18 \$8 \$4 \$26 pfet_05v0 L=0.5U W=0.66U AS=0.2046P AD=0.2046P PS=1.28U
+ PD=1.28U
M$11 VDD A \$18 \$26 pfet_05v0 L=0.5U W=0.66U AS=0.2046P AD=0.3456P PS=1.28U
+ PD=1.78U
M$12 \$18 B VDD \$26 pfet_05v0 L=0.5U W=0.66U AS=0.3456P AD=0.1716P PS=1.78U
+ PD=1.18U
M$13 VDD CI \$18 \$26 pfet_05v0 L=0.5U W=0.66U AS=0.1716P AD=0.2904P PS=1.18U
+ PD=2.2U
M$14 VDD \$4 S \$26 pfet_05v0 L=0.5U W=1.215U AS=0.5346P AD=0.3969P PS=3.31U
+ PD=2.055U
M$15 \$7 B VSS VSUB nfet_05v0 L=0.6U W=0.38U AS=0.2112P AD=0.1672P PS=1.5U
+ PD=1.64U
M$16 \$7 A VSS VSUB nfet_05v0 L=0.6U W=0.38U AS=0.2112P AD=0.2112P PS=1.5U
+ PD=1.5U
M$17 \$8 CI \$7 VSUB nfet_05v0 L=0.6U W=0.38U AS=0.2112P AD=0.0988P PS=1.5U
+ PD=0.9U
M$18 \$12 B \$8 VSUB nfet_05v0 L=0.6U W=0.38U AS=0.0988P AD=0.0456P PS=0.9U
+ PD=0.62U
M$19 \$12 A VSS VSUB nfet_05v0 L=0.6U W=0.38U AS=0.2363P AD=0.0456P PS=1.555U
+ PD=0.62U
M$20 CO \$8 VSS VSUB nfet_05v0 L=0.6U W=0.815U AS=0.2363P AD=0.3586P PS=1.555U
+ PD=2.51U
M$21 VSS \$4 S VSUB nfet_05v0 L=0.6U W=0.71U AS=0.3124P AD=0.2132P PS=2.3U
+ PD=1.45U
M$22 \$10 A VSS VSUB nfet_05v0 L=0.6U W=0.38U AS=0.2132P AD=0.0456P PS=1.45U
+ PD=0.62U
M$23 \$13 B \$10 VSUB nfet_05v0 L=0.6U W=0.38U AS=0.0456P AD=0.0456P PS=0.62U
+ PD=0.62U
M$24 \$4 CI \$13 VSUB nfet_05v0 L=0.6U W=0.38U AS=0.0456P AD=0.0988P PS=0.62U
+ PD=0.9U
M$25 \$6 \$8 \$4 VSUB nfet_05v0 L=0.6U W=0.38U AS=0.0988P AD=0.0988P PS=0.9U
+ PD=0.9U
M$26 \$6 A VSS VSUB nfet_05v0 L=0.6U W=0.38U AS=0.2112P AD=0.0988P PS=1.5U
+ PD=0.9U
M$27 \$6 B VSS VSUB nfet_05v0 L=0.6U W=0.38U AS=0.2112P AD=0.0988P PS=1.5U
+ PD=0.9U
M$28 VSS CI \$6 VSUB nfet_05v0 L=0.6U W=0.38U AS=0.0988P AD=0.1672P PS=0.9U
+ PD=1.64U
.ENDS gf180mcu_fd_sc_mcu7t5v0__addf_1
