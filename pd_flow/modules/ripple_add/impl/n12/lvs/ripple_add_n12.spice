* ripple_add N=12: schematic from ripple_add.pnl.v + PDK cell SPICE (gf180mcu_fd_sc_mcu7t5v0.spice); generated by impl/scripts/make_cdl.py

.SUBCKT ripple_add a[0] a[1] a[2] a[3] a[4] a[5] a[6] a[7] a[8] a[9] a[10] a[11] b[0] b[1] b[2] b[3] b[4] b[5] b[6] b[7] b[8] b[9] b[10] b[11] cin s[0] s[1] s[2] s[3] s[4] s[5] s[6] s[7] s[8] s[9] s[10] s[11] VPWR VGND
XFILLER_11_10 VPWR VPWR VGND VGND gf180mcu_fd_sc_mcu7t5v0__fill_2
XFILLER_11_2 VPWR VPWR VGND VGND gf180mcu_fd_sc_mcu7t5v0__fillcap_8
XPHY_EDGE_ROW_0_Left_12 VPWR VPWR VGND VGND gf180mcu_fd_sc_mcu7t5v0__endcap
XPHY_EDGE_ROW_0_Right_0 VPWR VPWR VGND VGND gf180mcu_fd_sc_mcu7t5v0__endcap
XPHY_EDGE_ROW_10_Left_22 VPWR VPWR VGND VGND gf180mcu_fd_sc_mcu7t5v0__endcap
XPHY_EDGE_ROW_10_Right_10 VPWR VPWR VGND VGND gf180mcu_fd_sc_mcu7t5v0__endcap
XPHY_EDGE_ROW_11_Left_23 VPWR VPWR VGND VGND gf180mcu_fd_sc_mcu7t5v0__endcap
XPHY_EDGE_ROW_11_Right_11 VPWR VPWR VGND VGND gf180mcu_fd_sc_mcu7t5v0__endcap
XPHY_EDGE_ROW_1_Left_13 VPWR VPWR VGND VGND gf180mcu_fd_sc_mcu7t5v0__endcap
XPHY_EDGE_ROW_1_Right_1 VPWR VPWR VGND VGND gf180mcu_fd_sc_mcu7t5v0__endcap
XPHY_EDGE_ROW_2_Left_14 VPWR VPWR VGND VGND gf180mcu_fd_sc_mcu7t5v0__endcap
XPHY_EDGE_ROW_2_Right_2 VPWR VPWR VGND VGND gf180mcu_fd_sc_mcu7t5v0__endcap
XPHY_EDGE_ROW_3_Left_15 VPWR VPWR VGND VGND gf180mcu_fd_sc_mcu7t5v0__endcap
XPHY_EDGE_ROW_3_Right_3 VPWR VPWR VGND VGND gf180mcu_fd_sc_mcu7t5v0__endcap
XPHY_EDGE_ROW_4_Left_16 VPWR VPWR VGND VGND gf180mcu_fd_sc_mcu7t5v0__endcap
XPHY_EDGE_ROW_4_Right_4 VPWR VPWR VGND VGND gf180mcu_fd_sc_mcu7t5v0__endcap
XPHY_EDGE_ROW_5_Left_17 VPWR VPWR VGND VGND gf180mcu_fd_sc_mcu7t5v0__endcap
XPHY_EDGE_ROW_5_Right_5 VPWR VPWR VGND VGND gf180mcu_fd_sc_mcu7t5v0__endcap
XPHY_EDGE_ROW_6_Left_18 VPWR VPWR VGND VGND gf180mcu_fd_sc_mcu7t5v0__endcap
XPHY_EDGE_ROW_6_Right_6 VPWR VPWR VGND VGND gf180mcu_fd_sc_mcu7t5v0__endcap
XPHY_EDGE_ROW_7_Left_19 VPWR VPWR VGND VGND gf180mcu_fd_sc_mcu7t5v0__endcap
XPHY_EDGE_ROW_7_Right_7 VPWR VPWR VGND VGND gf180mcu_fd_sc_mcu7t5v0__endcap
XPHY_EDGE_ROW_8_Left_20 VPWR VPWR VGND VGND gf180mcu_fd_sc_mcu7t5v0__endcap
XPHY_EDGE_ROW_8_Right_8 VPWR VPWR VGND VGND gf180mcu_fd_sc_mcu7t5v0__endcap
XPHY_EDGE_ROW_9_Left_21 VPWR VPWR VGND VGND gf180mcu_fd_sc_mcu7t5v0__endcap
XPHY_EDGE_ROW_9_Right_9 VPWR VPWR VGND VGND gf180mcu_fd_sc_mcu7t5v0__endcap
Xbitslice_0__u_fa a[0] b[0] cin c[1] s[0] VPWR VPWR VGND VGND gf180mcu_fd_sc_mcu7t5v0__addf_1
Xbitslice_10__u_fa a[10] b[10] c[10] c[11] s[10] VPWR VPWR VGND VGND gf180mcu_fd_sc_mcu7t5v0__addf_1
Xbitslice_1__u_fa a[1] b[1] c[1] c[2] s[1] VPWR VPWR VGND VGND gf180mcu_fd_sc_mcu7t5v0__addf_1
Xbitslice_2__u_fa a[2] b[2] c[2] c[3] s[2] VPWR VPWR VGND VGND gf180mcu_fd_sc_mcu7t5v0__addf_1
Xbitslice_3__u_fa a[3] b[3] c[3] c[4] s[3] VPWR VPWR VGND VGND gf180mcu_fd_sc_mcu7t5v0__addf_1
Xbitslice_4__u_fa a[4] b[4] c[4] c[5] s[4] VPWR VPWR VGND VGND gf180mcu_fd_sc_mcu7t5v0__addf_1
Xbitslice_5__u_fa a[5] b[5] c[5] c[6] s[5] VPWR VPWR VGND VGND gf180mcu_fd_sc_mcu7t5v0__addf_1
Xbitslice_6__u_fa a[6] b[6] c[6] c[7] s[6] VPWR VPWR VGND VGND gf180mcu_fd_sc_mcu7t5v0__addf_1
Xbitslice_7__u_fa a[7] b[7] c[7] c[8] s[7] VPWR VPWR VGND VGND gf180mcu_fd_sc_mcu7t5v0__addf_1
Xbitslice_8__u_fa a[8] b[8] c[8] c[9] s[8] VPWR VPWR VGND VGND gf180mcu_fd_sc_mcu7t5v0__addf_1
Xbitslice_9__u_fa a[9] b[9] c[9] c[10] s[9] VPWR VPWR VGND VGND gf180mcu_fd_sc_mcu7t5v0__addf_1
Xu_msb_x3 b[11] a[11] c[11] s[11] VPWR VPWR VGND VGND gf180mcu_fd_sc_mcu7t5v0__xor3_1
.ENDS ripple_add

.SUBCKT gf180mcu_fd_sc_mcu7t5v0__addf_1 A B CI CO S VDD VNW VPW VSS
X_M51 VSS net9 S VPW nfet_05v0 W=7.1e-07 L=6e-07
X_M46 net9 CI net47 VPW nfet_05v0 W=3.8e-07 L=6e-07
X_M45 net42 CI VSS VPW nfet_05v0 W=3.8e-07 L=6e-07
X_M34 CO net7 VSS VPW nfet_05v0 W=8.15e-07 L=6e-07
X_M33 VDD net9 S VNW pfet_05v0 W=1.215e-06 L=5e-07
X_M28 net9 CI net29 VNW pfet_05v0 W=6.6e-07 L=5e-07
X_M24 net9 net7 net3 VNW pfet_05v0 W=6.6e-07 L=5e-07
X_M25 net3 A VDD VNW pfet_05v0 W=6.6e-07 L=5e-07
X_M26 VDD B net3 VNW pfet_05v0 W=6.6e-07 L=5e-07
X_M27 net3 CI VDD VNW pfet_05v0 W=6.6e-07 L=5e-07
X_M21 net7 CI net1 VNW pfet_05v0 W=7e-07 L=5e-07
X_M20 net19 B net7 VNW pfet_05v0 W=7e-07 L=5e-07
X_M18 VDD A net19 VNW pfet_05v0 W=7e-07 L=5e-07
X_M17 CO net7 VDD VNW pfet_05v0 W=1.215e-06 L=5e-07
X_M48 net47 B net49 VPW nfet_05v0 W=3.8e-07 L=6e-07
X_M41 net9 net7 net42 VPW nfet_05v0 W=3.8e-07 L=6e-07
X_M43 net42 A VSS VPW nfet_05v0 W=3.8e-07 L=6e-07
X_M44 VSS B net42 VPW nfet_05v0 W=3.8e-07 L=6e-07
X_M38 net7 CI net5 VPW nfet_05v0 W=3.8e-07 L=6e-07
X_M37 net36 B net7 VPW nfet_05v0 W=3.8e-07 L=6e-07
X_M35 VSS A net36 VPW nfet_05v0 W=3.8e-07 L=6e-07
X_M30 net29 B net31 VNW pfet_05v0 W=6.6e-07 L=5e-07
X_M23 VDD B net1 VNW pfet_05v0 W=7e-07 L=5e-07
X_M22 net1 A VDD VNW pfet_05v0 W=7e-07 L=5e-07
X_M50 net49 A VSS VPW nfet_05v0 W=3.8e-07 L=6e-07
X_M40 VSS B net5 VPW nfet_05v0 W=3.8e-07 L=6e-07
X_M39 net5 A VSS VPW nfet_05v0 W=3.8e-07 L=6e-07
X_M32 net31 A VDD VNW pfet_05v0 W=6.6e-07 L=5e-07
.ENDS

.SUBCKT gf180mcu_fd_sc_mcu7t5v0__endcap VDD VNW VPW VSS
.ENDS

.SUBCKT gf180mcu_fd_sc_mcu7t5v0__fill_2 VDD VNW VPW VSS
.ENDS

.SUBCKT gf180mcu_fd_sc_mcu7t5v0__fillcap_8 VDD VNW VPW VSS
X_i_17 net_3 net_2 VSS VPW nfet_05v0 W=8.2e-07 L=1e-06
X_i_17_23 net_4 net_5 VSS VPW nfet_05v0 W=8.2e-07 L=1e-06
X_i_19 VDD net_3 net_2 VNW pfet_05v0 W=1.22e-06 L=1e-06
X_i_19_7 VDD net_4 net_5 VNW pfet_05v0 W=1.22e-06 L=1e-06
.ENDS

.SUBCKT gf180mcu_fd_sc_mcu7t5v0__xor3_1 A1 A2 A3 Z VDD VNW VPW VSS
X_i_12 I A2 VSS VPW nfet_05v0 W=3.6e-07 L=6e-07
X_i_13 VSS A1 I VPW nfet_05v0 W=3.6e-07 L=6e-07
X_i_2 I2 I VSS VPW nfet_05v0 W=3.6e-07 L=6e-07
X_i_0 net_0 A1 I2 VPW nfet_05v0 W=3.6e-07 L=6e-07
X_i_1 VSS A2 net_0 VPW nfet_05v0 W=3.6e-07 L=6e-07
X_i_16 I3 I2 VSS VPW nfet_05v0 W=3.6e-07 L=6e-07
X_i_17 VSS A3 I3 VPW nfet_05v0 W=3.6e-07 L=6e-07
X_i_8 Z I3 VSS VPW nfet_05v0 W=8.2e-07 L=6e-07
X_i_6 net_2 A3 Z VPW nfet_05v0 W=8.2e-07 L=6e-07
X_i_7 VSS I2 net_2 VPW nfet_05v0 W=8.2e-07 L=6e-07
X_i_14 net_4 A2 I VNW pfet_05v0 W=3.6e-07 L=5e-07
X_i_15 VDD A1 net_4 VNW pfet_05v0 W=3.6e-07 L=5e-07
X_i_5 net_1 I VDD VNW pfet_05v0 W=5.65e-07 L=5e-07
X_i_3 I2 A1 net_1 VNW pfet_05v0 W=5.65e-07 L=5e-07
X_i_4 net_1 A2 I2 VNW pfet_05v0 W=5.65e-07 L=5e-07
X_i_18 net_5 I2 I3 VNW pfet_05v0 W=5.65e-07 L=5e-07
X_i_19 VDD A3 net_5 VNW pfet_05v0 W=5.65e-07 L=5e-07
X_i_11 net_3 I3 VDD VNW pfet_05v0 W=1.22e-06 L=5e-07
X_i_9 Z A3 net_3 VNW pfet_05v0 W=1.22e-06 L=5e-07
X_i_10 net_3 I2 Z VNW pfet_05v0 W=1.22e-06 L=5e-07
.ENDS
