* ripple_add N=12 carry-chain delay from a[0], corner tt
.include /Users/samuelzhang/ttsetup/pdk/ciel/gf180mcu/versions/54435919abffb937387ec956209f9cf5fd2dfbee/gf180mcuD/libs.tech/ngspice/design.ngspice
.lib /Users/samuelzhang/ttsetup/pdk/ciel/gf180mcu/versions/54435919abffb937387ec956209f9cf5fd2dfbee/gf180mcuD/libs.tech/ngspice/sm141064.ngspice typical
.include ../pex/ripple_add_n12_pex.spice
.temp 25
.options method=gear reltol=1e-4 abstol=1e-13
VDD vpwr 0 3.3
X1 0 vpwr a_0 a_10 a_11 a_1 a_2 a_3 a_4 a_5 a_6 a_7 a_8 a_9 b_0 b_10 b_11 b_1 b_2 b_3 b_4 b_5 b_6 b_7 b_8 b_9 cin s_0 s_10 s_11 s_1 s_2 s_3 s_4 s_5 s_6 s_7 s_8 s_9 ripple_add
C_s_0 s_0 0 2e-14
C_s_1 s_1 0 2e-14
C_s_2 s_2 0 2e-14
C_s_3 s_3 0 2e-14
C_s_4 s_4 0 2e-14
C_s_5 s_5 0 2e-14
C_s_6 s_6 0 2e-14
C_s_7 s_7 0 2e-14
C_s_8 s_8 0 2e-14
C_s_9 s_9 0 2e-14
C_s_10 s_10 0 2e-14
C_s_11 s_11 0 2e-14
V_a_0 a_0 0 PWL(0.000000e+00 0.0000 4.200000e-08 0.0000 4.237500e-08 3.3000 8.200000e-08 3.3000 8.237500e-08 0.0000)
V_a_1 a_1 0 PWL(0.000000e+00 3.3000)
V_a_2 a_2 0 PWL(0.000000e+00 3.3000)
V_a_3 a_3 0 PWL(0.000000e+00 3.3000)
V_a_4 a_4 0 PWL(0.000000e+00 3.3000)
V_a_5 a_5 0 PWL(0.000000e+00 3.3000)
V_a_6 a_6 0 PWL(0.000000e+00 3.3000)
V_a_7 a_7 0 PWL(0.000000e+00 3.3000)
V_a_8 a_8 0 PWL(0.000000e+00 3.3000)
V_a_9 a_9 0 PWL(0.000000e+00 3.3000)
V_a_10 a_10 0 PWL(0.000000e+00 3.3000)
V_a_11 a_11 0 PWL(0.000000e+00 3.3000)
V_b_0 b_0 0 PWL(0.000000e+00 0.0000)
V_b_1 b_1 0 PWL(0.000000e+00 0.0000)
V_b_2 b_2 0 PWL(0.000000e+00 0.0000)
V_b_3 b_3 0 PWL(0.000000e+00 0.0000)
V_b_4 b_4 0 PWL(0.000000e+00 0.0000)
V_b_5 b_5 0 PWL(0.000000e+00 0.0000)
V_b_6 b_6 0 PWL(0.000000e+00 0.0000)
V_b_7 b_7 0 PWL(0.000000e+00 0.0000)
V_b_8 b_8 0 PWL(0.000000e+00 0.0000)
V_b_9 b_9 0 PWL(0.000000e+00 0.0000)
V_b_10 b_10 0 PWL(0.000000e+00 0.0000)
V_b_11 b_11 0 PWL(0.000000e+00 0.0000)
V_cin cin 0 PWL(0.000000e+00 3.3000)
.meas tran d_rise_s0 TRIG v(a_0) VAL=1.65 RISE=1 TD=4.100000e-08 TARG v(s_0) VAL=1.65 CROSS=1 TD=4.100000e-08
.meas tran tl1090_rise_s0 WHEN v(s_0)=0.33 CROSS=1 TD=4.100000e-08
.meas tran th1090_rise_s0 WHEN v(s_0)=2.9699999999999998 CROSS=1 TD=4.100000e-08
.meas tran tl3070_rise_s0 WHEN v(s_0)=0.9899999999999999 CROSS=1 TD=4.100000e-08
.meas tran th3070_rise_s0 WHEN v(s_0)=2.3099999999999996 CROSS=1 TD=4.100000e-08
.meas tran d_rise_s1 TRIG v(a_0) VAL=1.65 RISE=1 TD=4.100000e-08 TARG v(s_1) VAL=1.65 CROSS=1 TD=4.100000e-08
.meas tran tl1090_rise_s1 WHEN v(s_1)=0.33 CROSS=1 TD=4.100000e-08
.meas tran th1090_rise_s1 WHEN v(s_1)=2.9699999999999998 CROSS=1 TD=4.100000e-08
.meas tran tl3070_rise_s1 WHEN v(s_1)=0.9899999999999999 CROSS=1 TD=4.100000e-08
.meas tran th3070_rise_s1 WHEN v(s_1)=2.3099999999999996 CROSS=1 TD=4.100000e-08
.meas tran d_rise_s2 TRIG v(a_0) VAL=1.65 RISE=1 TD=4.100000e-08 TARG v(s_2) VAL=1.65 CROSS=1 TD=4.100000e-08
.meas tran tl1090_rise_s2 WHEN v(s_2)=0.33 CROSS=1 TD=4.100000e-08
.meas tran th1090_rise_s2 WHEN v(s_2)=2.9699999999999998 CROSS=1 TD=4.100000e-08
.meas tran tl3070_rise_s2 WHEN v(s_2)=0.9899999999999999 CROSS=1 TD=4.100000e-08
.meas tran th3070_rise_s2 WHEN v(s_2)=2.3099999999999996 CROSS=1 TD=4.100000e-08
.meas tran d_rise_s3 TRIG v(a_0) VAL=1.65 RISE=1 TD=4.100000e-08 TARG v(s_3) VAL=1.65 CROSS=1 TD=4.100000e-08
.meas tran tl1090_rise_s3 WHEN v(s_3)=0.33 CROSS=1 TD=4.100000e-08
.meas tran th1090_rise_s3 WHEN v(s_3)=2.9699999999999998 CROSS=1 TD=4.100000e-08
.meas tran tl3070_rise_s3 WHEN v(s_3)=0.9899999999999999 CROSS=1 TD=4.100000e-08
.meas tran th3070_rise_s3 WHEN v(s_3)=2.3099999999999996 CROSS=1 TD=4.100000e-08
.meas tran d_rise_s4 TRIG v(a_0) VAL=1.65 RISE=1 TD=4.100000e-08 TARG v(s_4) VAL=1.65 CROSS=1 TD=4.100000e-08
.meas tran tl1090_rise_s4 WHEN v(s_4)=0.33 CROSS=1 TD=4.100000e-08
.meas tran th1090_rise_s4 WHEN v(s_4)=2.9699999999999998 CROSS=1 TD=4.100000e-08
.meas tran tl3070_rise_s4 WHEN v(s_4)=0.9899999999999999 CROSS=1 TD=4.100000e-08
.meas tran th3070_rise_s4 WHEN v(s_4)=2.3099999999999996 CROSS=1 TD=4.100000e-08
.meas tran d_rise_s5 TRIG v(a_0) VAL=1.65 RISE=1 TD=4.100000e-08 TARG v(s_5) VAL=1.65 CROSS=1 TD=4.100000e-08
.meas tran tl1090_rise_s5 WHEN v(s_5)=0.33 CROSS=1 TD=4.100000e-08
.meas tran th1090_rise_s5 WHEN v(s_5)=2.9699999999999998 CROSS=1 TD=4.100000e-08
.meas tran tl3070_rise_s5 WHEN v(s_5)=0.9899999999999999 CROSS=1 TD=4.100000e-08
.meas tran th3070_rise_s5 WHEN v(s_5)=2.3099999999999996 CROSS=1 TD=4.100000e-08
.meas tran d_rise_s6 TRIG v(a_0) VAL=1.65 RISE=1 TD=4.100000e-08 TARG v(s_6) VAL=1.65 CROSS=1 TD=4.100000e-08
.meas tran tl1090_rise_s6 WHEN v(s_6)=0.33 CROSS=1 TD=4.100000e-08
.meas tran th1090_rise_s6 WHEN v(s_6)=2.9699999999999998 CROSS=1 TD=4.100000e-08
.meas tran tl3070_rise_s6 WHEN v(s_6)=0.9899999999999999 CROSS=1 TD=4.100000e-08
.meas tran th3070_rise_s6 WHEN v(s_6)=2.3099999999999996 CROSS=1 TD=4.100000e-08
.meas tran d_rise_s7 TRIG v(a_0) VAL=1.65 RISE=1 TD=4.100000e-08 TARG v(s_7) VAL=1.65 CROSS=1 TD=4.100000e-08
.meas tran tl1090_rise_s7 WHEN v(s_7)=0.33 CROSS=1 TD=4.100000e-08
.meas tran th1090_rise_s7 WHEN v(s_7)=2.9699999999999998 CROSS=1 TD=4.100000e-08
.meas tran tl3070_rise_s7 WHEN v(s_7)=0.9899999999999999 CROSS=1 TD=4.100000e-08
.meas tran th3070_rise_s7 WHEN v(s_7)=2.3099999999999996 CROSS=1 TD=4.100000e-08
.meas tran d_rise_s8 TRIG v(a_0) VAL=1.65 RISE=1 TD=4.100000e-08 TARG v(s_8) VAL=1.65 CROSS=1 TD=4.100000e-08
.meas tran tl1090_rise_s8 WHEN v(s_8)=0.33 CROSS=1 TD=4.100000e-08
.meas tran th1090_rise_s8 WHEN v(s_8)=2.9699999999999998 CROSS=1 TD=4.100000e-08
.meas tran tl3070_rise_s8 WHEN v(s_8)=0.9899999999999999 CROSS=1 TD=4.100000e-08
.meas tran th3070_rise_s8 WHEN v(s_8)=2.3099999999999996 CROSS=1 TD=4.100000e-08
.meas tran d_rise_s9 TRIG v(a_0) VAL=1.65 RISE=1 TD=4.100000e-08 TARG v(s_9) VAL=1.65 CROSS=1 TD=4.100000e-08
.meas tran tl1090_rise_s9 WHEN v(s_9)=0.33 CROSS=1 TD=4.100000e-08
.meas tran th1090_rise_s9 WHEN v(s_9)=2.9699999999999998 CROSS=1 TD=4.100000e-08
.meas tran tl3070_rise_s9 WHEN v(s_9)=0.9899999999999999 CROSS=1 TD=4.100000e-08
.meas tran th3070_rise_s9 WHEN v(s_9)=2.3099999999999996 CROSS=1 TD=4.100000e-08
.meas tran d_rise_s10 TRIG v(a_0) VAL=1.65 RISE=1 TD=4.100000e-08 TARG v(s_10) VAL=1.65 CROSS=1 TD=4.100000e-08
.meas tran tl1090_rise_s10 WHEN v(s_10)=0.33 CROSS=1 TD=4.100000e-08
.meas tran th1090_rise_s10 WHEN v(s_10)=2.9699999999999998 CROSS=1 TD=4.100000e-08
.meas tran tl3070_rise_s10 WHEN v(s_10)=0.9899999999999999 CROSS=1 TD=4.100000e-08
.meas tran th3070_rise_s10 WHEN v(s_10)=2.3099999999999996 CROSS=1 TD=4.100000e-08
.meas tran d_rise_s11 TRIG v(a_0) VAL=1.65 RISE=1 TD=4.100000e-08 TARG v(s_11) VAL=1.65 CROSS=1 TD=4.100000e-08
.meas tran tl1090_rise_s11 WHEN v(s_11)=0.33 CROSS=1 TD=4.100000e-08
.meas tran th1090_rise_s11 WHEN v(s_11)=2.9699999999999998 CROSS=1 TD=4.100000e-08
.meas tran tl3070_rise_s11 WHEN v(s_11)=0.9899999999999999 CROSS=1 TD=4.100000e-08
.meas tran th3070_rise_s11 WHEN v(s_11)=2.3099999999999996 CROSS=1 TD=4.100000e-08
.meas tran d_fall_s0 TRIG v(a_0) VAL=1.65 FALL=1 TD=8.100000e-08 TARG v(s_0) VAL=1.65 CROSS=1 TD=8.100000e-08
.meas tran tl1090_fall_s0 WHEN v(s_0)=0.33 CROSS=1 TD=8.100000e-08
.meas tran th1090_fall_s0 WHEN v(s_0)=2.9699999999999998 CROSS=1 TD=8.100000e-08
.meas tran tl3070_fall_s0 WHEN v(s_0)=0.9899999999999999 CROSS=1 TD=8.100000e-08
.meas tran th3070_fall_s0 WHEN v(s_0)=2.3099999999999996 CROSS=1 TD=8.100000e-08
.meas tran d_fall_s1 TRIG v(a_0) VAL=1.65 FALL=1 TD=8.100000e-08 TARG v(s_1) VAL=1.65 CROSS=1 TD=8.100000e-08
.meas tran tl1090_fall_s1 WHEN v(s_1)=0.33 CROSS=1 TD=8.100000e-08
.meas tran th1090_fall_s1 WHEN v(s_1)=2.9699999999999998 CROSS=1 TD=8.100000e-08
.meas tran tl3070_fall_s1 WHEN v(s_1)=0.9899999999999999 CROSS=1 TD=8.100000e-08
.meas tran th3070_fall_s1 WHEN v(s_1)=2.3099999999999996 CROSS=1 TD=8.100000e-08
.meas tran d_fall_s2 TRIG v(a_0) VAL=1.65 FALL=1 TD=8.100000e-08 TARG v(s_2) VAL=1.65 CROSS=1 TD=8.100000e-08
.meas tran tl1090_fall_s2 WHEN v(s_2)=0.33 CROSS=1 TD=8.100000e-08
.meas tran th1090_fall_s2 WHEN v(s_2)=2.9699999999999998 CROSS=1 TD=8.100000e-08
.meas tran tl3070_fall_s2 WHEN v(s_2)=0.9899999999999999 CROSS=1 TD=8.100000e-08
.meas tran th3070_fall_s2 WHEN v(s_2)=2.3099999999999996 CROSS=1 TD=8.100000e-08
.meas tran d_fall_s3 TRIG v(a_0) VAL=1.65 FALL=1 TD=8.100000e-08 TARG v(s_3) VAL=1.65 CROSS=1 TD=8.100000e-08
.meas tran tl1090_fall_s3 WHEN v(s_3)=0.33 CROSS=1 TD=8.100000e-08
.meas tran th1090_fall_s3 WHEN v(s_3)=2.9699999999999998 CROSS=1 TD=8.100000e-08
.meas tran tl3070_fall_s3 WHEN v(s_3)=0.9899999999999999 CROSS=1 TD=8.100000e-08
.meas tran th3070_fall_s3 WHEN v(s_3)=2.3099999999999996 CROSS=1 TD=8.100000e-08
.meas tran d_fall_s4 TRIG v(a_0) VAL=1.65 FALL=1 TD=8.100000e-08 TARG v(s_4) VAL=1.65 CROSS=1 TD=8.100000e-08
.meas tran tl1090_fall_s4 WHEN v(s_4)=0.33 CROSS=1 TD=8.100000e-08
.meas tran th1090_fall_s4 WHEN v(s_4)=2.9699999999999998 CROSS=1 TD=8.100000e-08
.meas tran tl3070_fall_s4 WHEN v(s_4)=0.9899999999999999 CROSS=1 TD=8.100000e-08
.meas tran th3070_fall_s4 WHEN v(s_4)=2.3099999999999996 CROSS=1 TD=8.100000e-08
.meas tran d_fall_s5 TRIG v(a_0) VAL=1.65 FALL=1 TD=8.100000e-08 TARG v(s_5) VAL=1.65 CROSS=1 TD=8.100000e-08
.meas tran tl1090_fall_s5 WHEN v(s_5)=0.33 CROSS=1 TD=8.100000e-08
.meas tran th1090_fall_s5 WHEN v(s_5)=2.9699999999999998 CROSS=1 TD=8.100000e-08
.meas tran tl3070_fall_s5 WHEN v(s_5)=0.9899999999999999 CROSS=1 TD=8.100000e-08
.meas tran th3070_fall_s5 WHEN v(s_5)=2.3099999999999996 CROSS=1 TD=8.100000e-08
.meas tran d_fall_s6 TRIG v(a_0) VAL=1.65 FALL=1 TD=8.100000e-08 TARG v(s_6) VAL=1.65 CROSS=1 TD=8.100000e-08
.meas tran tl1090_fall_s6 WHEN v(s_6)=0.33 CROSS=1 TD=8.100000e-08
.meas tran th1090_fall_s6 WHEN v(s_6)=2.9699999999999998 CROSS=1 TD=8.100000e-08
.meas tran tl3070_fall_s6 WHEN v(s_6)=0.9899999999999999 CROSS=1 TD=8.100000e-08
.meas tran th3070_fall_s6 WHEN v(s_6)=2.3099999999999996 CROSS=1 TD=8.100000e-08
.meas tran d_fall_s7 TRIG v(a_0) VAL=1.65 FALL=1 TD=8.100000e-08 TARG v(s_7) VAL=1.65 CROSS=1 TD=8.100000e-08
.meas tran tl1090_fall_s7 WHEN v(s_7)=0.33 CROSS=1 TD=8.100000e-08
.meas tran th1090_fall_s7 WHEN v(s_7)=2.9699999999999998 CROSS=1 TD=8.100000e-08
.meas tran tl3070_fall_s7 WHEN v(s_7)=0.9899999999999999 CROSS=1 TD=8.100000e-08
.meas tran th3070_fall_s7 WHEN v(s_7)=2.3099999999999996 CROSS=1 TD=8.100000e-08
.meas tran d_fall_s8 TRIG v(a_0) VAL=1.65 FALL=1 TD=8.100000e-08 TARG v(s_8) VAL=1.65 CROSS=1 TD=8.100000e-08
.meas tran tl1090_fall_s8 WHEN v(s_8)=0.33 CROSS=1 TD=8.100000e-08
.meas tran th1090_fall_s8 WHEN v(s_8)=2.9699999999999998 CROSS=1 TD=8.100000e-08
.meas tran tl3070_fall_s8 WHEN v(s_8)=0.9899999999999999 CROSS=1 TD=8.100000e-08
.meas tran th3070_fall_s8 WHEN v(s_8)=2.3099999999999996 CROSS=1 TD=8.100000e-08
.meas tran d_fall_s9 TRIG v(a_0) VAL=1.65 FALL=1 TD=8.100000e-08 TARG v(s_9) VAL=1.65 CROSS=1 TD=8.100000e-08
.meas tran tl1090_fall_s9 WHEN v(s_9)=0.33 CROSS=1 TD=8.100000e-08
.meas tran th1090_fall_s9 WHEN v(s_9)=2.9699999999999998 CROSS=1 TD=8.100000e-08
.meas tran tl3070_fall_s9 WHEN v(s_9)=0.9899999999999999 CROSS=1 TD=8.100000e-08
.meas tran th3070_fall_s9 WHEN v(s_9)=2.3099999999999996 CROSS=1 TD=8.100000e-08
.meas tran d_fall_s10 TRIG v(a_0) VAL=1.65 FALL=1 TD=8.100000e-08 TARG v(s_10) VAL=1.65 CROSS=1 TD=8.100000e-08
.meas tran tl1090_fall_s10 WHEN v(s_10)=0.33 CROSS=1 TD=8.100000e-08
.meas tran th1090_fall_s10 WHEN v(s_10)=2.9699999999999998 CROSS=1 TD=8.100000e-08
.meas tran tl3070_fall_s10 WHEN v(s_10)=0.9899999999999999 CROSS=1 TD=8.100000e-08
.meas tran th3070_fall_s10 WHEN v(s_10)=2.3099999999999996 CROSS=1 TD=8.100000e-08
.meas tran d_fall_s11 TRIG v(a_0) VAL=1.65 FALL=1 TD=8.100000e-08 TARG v(s_11) VAL=1.65 CROSS=1 TD=8.100000e-08
.meas tran tl1090_fall_s11 WHEN v(s_11)=0.33 CROSS=1 TD=8.100000e-08
.meas tran th1090_fall_s11 WHEN v(s_11)=2.9699999999999998 CROSS=1 TD=8.100000e-08
.meas tran tl3070_fall_s11 WHEN v(s_11)=0.9899999999999999 CROSS=1 TD=8.100000e-08
.meas tran th3070_fall_s11 WHEN v(s_11)=2.3099999999999996 CROSS=1 TD=8.100000e-08
.tran 10p 1.220000e-07
.end
