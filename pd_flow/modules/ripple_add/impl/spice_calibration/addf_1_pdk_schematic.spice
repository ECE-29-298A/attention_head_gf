.SUBCKT addf_sch A B CI CO S VDD VNW VPW VSS
X_M51 VSS net9 S VPW nfet_05v0 W=7.1e-07 L=6e-07
X_M46 net9 CI net47 VPW nfet_05v0 W=3.8e-07 L=6e-07
X_M45 net42 CI VSS VPW nfet_05v0 W=3.8e-07 L=6e-07
X_M34 CO net7 VSS VPW nfet_05v0 W=8.15e-07 L=6e-07
X_M33 VDD net9 S VNW pfet_05v0 W=1.215e-06 L=5e-07
X_M28 net9 CI net29 VNW pfet_05v0 W=6.6e-07 L=5e-07
X_M24 net9 net7 net3 VNW pfet_05v0 W=6.6e-07 L=5e-07
X_M25 net3 A VDD VNW pfet_05v0 W=6.6e-07 L=5e-07
X_M26 VDD B net3 VNW pfet_05v0 W=6.6e-07 L=5e-07
X_M27 net3 CI VDD VNW pfet_05v0 W=6.6e-07 L=5e-07
X_M21 net7 CI net1 VNW pfet_05v0 W=7e-07 L=5e-07
X_M20 net19 B net7 VNW pfet_05v0 W=7e-07 L=5e-07
X_M18 VDD A net19 VNW pfet_05v0 W=7e-07 L=5e-07
X_M17 CO net7 VDD VNW pfet_05v0 W=1.215e-06 L=5e-07
X_M48 net47 B net49 VPW nfet_05v0 W=3.8e-07 L=6e-07
X_M41 net9 net7 net42 VPW nfet_05v0 W=3.8e-07 L=6e-07
X_M43 net42 A VSS VPW nfet_05v0 W=3.8e-07 L=6e-07
X_M44 VSS B net42 VPW nfet_05v0 W=3.8e-07 L=6e-07
X_M38 net7 CI net5 VPW nfet_05v0 W=3.8e-07 L=6e-07
X_M37 net36 B net7 VPW nfet_05v0 W=3.8e-07 L=6e-07
X_M35 VSS A net36 VPW nfet_05v0 W=3.8e-07 L=6e-07
X_M30 net29 B net31 VNW pfet_05v0 W=6.6e-07 L=5e-07
X_M23 VDD B net1 VNW pfet_05v0 W=7e-07 L=5e-07
X_M22 net1 A VDD VNW pfet_05v0 W=7e-07 L=5e-07
X_M50 net49 A VSS VPW nfet_05v0 W=3.8e-07 L=6e-07
X_M40 VSS B net5 VPW nfet_05v0 W=3.8e-07 L=6e-07
X_M39 net5 A VSS VPW nfet_05v0 W=3.8e-07 L=6e-07
X_M32 net31 A VDD VNW pfet_05v0 W=6.6e-07 L=5e-07
.ENDS
