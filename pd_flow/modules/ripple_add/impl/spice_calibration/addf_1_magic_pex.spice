* NGSPICE file created from addf_pex.ext - technology: gf180mcuD

.subckt addf_pex B CI CO S VDD VSS A VNW VPW
X0 a_1072_496# B VDD VNW pfet_05v0 ad=0.1716p pd=1.18u as=0.3456p ps=1.78u w=0.66u l=0.5u
X1 a_512_156# A VSS VPW nfet_05v0 ad=45.6f pd=0.62u as=0.2132p ps=1.45u w=0.38u l=0.6u
X2 a_124_46# CI a_680_496# VNW pfet_05v0 ad=0.2046p pd=1.28u as=0.1122p ps=1u w=0.66u l=0.5u
X3 a_3028_472# B a_952_112# VNW pfet_05v0 ad=0.119p pd=1.04u as=0.217p ps=1.32u w=0.7u l=0.5u
X4 VDD CI a_1072_496# VNW pfet_05v0 ad=0.2904p pd=2.2u as=0.1716p ps=1.18u w=0.66u l=0.5u
X5 a_1072_156# B VSS VPW nfet_05v0 ad=98.8f pd=0.9u as=0.2112p ps=1.5u w=0.38u l=0.6u
X6 a_680_496# B a_512_496# VNW pfet_05v0 ad=0.1122p pd=1u as=0.1122p ps=1u w=0.66u l=0.5u
X7 a_1072_156# a_952_112# a_124_46# VPW nfet_05v0 ad=98.8f pd=0.9u as=98.8f ps=0.9u w=0.38u l=0.6u
X8 VSS A a_3048_156# VPW nfet_05v0 ad=0.2363p pd=1.555u as=45.6f ps=0.62u w=0.38u l=0.6u
X9 VDD A a_1072_496# VNW pfet_05v0 ad=0.3456p pd=1.78u as=0.2046p ps=1.28u w=0.66u l=0.5u
X10 a_952_112# CI a_1992_156# VPW nfet_05v0 ad=98.8f pd=0.9u as=0.2112p ps=1.5u w=0.38u l=0.6u
X11 VDD a_124_46# S VNW pfet_05v0 ad=0.3969p pd=2.055u as=0.5346p ps=3.31u w=1.215u l=0.5u
X12 VDD A a_3028_472# VNW pfet_05v0 ad=0.4073p pd=2.055u as=0.119p ps=1.04u w=0.7u l=0.5u
X13 a_952_112# CI a_2012_472# VNW pfet_05v0 ad=0.217p pd=1.32u as=0.371p ps=1.76u w=0.7u l=0.5u
X14 CO a_952_112# VSS VPW nfet_05v0 ad=0.3586p pd=2.51u as=0.2363p ps=1.555u w=0.815u l=0.6u
X15 VDD B a_2012_472# VNW pfet_05v0 ad=0.3792p pd=1.9u as=0.308p ps=2.28u w=0.7u l=0.5u
X16 VSS a_124_46# S VPW nfet_05v0 ad=0.2132p pd=1.45u as=0.3124p ps=2.3u w=0.71u l=0.6u
X17 a_1072_496# a_952_112# a_124_46# VNW pfet_05v0 ad=0.2046p pd=1.28u as=0.2046p ps=1.28u w=0.66u l=0.5u
X18 a_512_496# A VDD VNW pfet_05v0 ad=0.1122p pd=1u as=0.3969p ps=2.055u w=0.66u l=0.5u
X19 VSS B a_1992_156# VPW nfet_05v0 ad=0.2112p pd=1.5u as=0.1672p ps=1.64u w=0.38u l=0.6u
X20 a_124_46# CI a_680_156# VPW nfet_05v0 ad=98.8f pd=0.9u as=45.6f ps=0.62u w=0.38u l=0.6u
X21 a_680_156# B a_512_156# VPW nfet_05v0 ad=45.6f pd=0.62u as=45.6f ps=0.62u w=0.38u l=0.6u
X22 CO a_952_112# VDD VNW pfet_05v0 ad=0.5346p pd=3.31u as=0.4073p ps=2.055u w=1.215u l=0.5u
X23 a_1992_156# A VSS VPW nfet_05v0 ad=0.2112p pd=1.5u as=0.2112p ps=1.5u w=0.38u l=0.6u
X24 VSS A a_1072_156# VPW nfet_05v0 ad=0.2112p pd=1.5u as=98.8f ps=0.9u w=0.38u l=0.6u
X25 a_3048_156# B a_952_112# VPW nfet_05v0 ad=45.6f pd=0.62u as=98.8f ps=0.9u w=0.38u l=0.6u
X26 VSS CI a_1072_156# VPW nfet_05v0 ad=0.1672p pd=1.64u as=98.8f ps=0.9u w=0.38u l=0.6u
X27 a_2012_472# A VDD VNW pfet_05v0 ad=0.371p pd=1.76u as=0.3792p ps=1.9u w=0.7u l=0.5u
C0 VSS S 0.0893f
C1 CO a_3028_472# 0
C2 a_2012_472# a_3028_472# 0
C3 VDD a_124_46# 0.28975f
C4 S a_680_156# 0
C5 A a_512_496# 0
C6 A B 0.45718f
C7 A a_952_112# 0.17352f
C8 a_2012_472# a_1072_496# 0.00406f
C9 CI a_1072_496# 0.00434f
C10 S a_124_46# 0.25717f
C11 VDD a_680_496# 0.00244f
C12 VNW a_1072_496# 0.0158f
C13 a_3048_156# a_952_112# 0.00316f
C14 A VDD 0.05808f
C15 S a_680_496# 0
C16 B a_952_112# 0.76226f
C17 A S 0.00303f
C18 CI a_2012_472# 0.00394f
C19 VDD a_512_496# 0.00258f
C20 B VDD 0.37958f
C21 CI a_1992_156# 0.69439f
C22 VDD a_952_112# 0.21418f
C23 CO VNW 0.03606f
C24 a_1072_496# a_124_46# 0.0139f
C25 VNW a_2012_472# 0.02499f
C26 CI VNW 0.40088f
C27 S a_512_496# 0
C28 B S 0.00123f
C29 S a_952_112# 0
C30 a_680_496# a_1072_496# 0
C31 S a_512_156# 0
C32 CO VSS 0.04628f
C33 VSS CI 0.2321f
C34 VSS a_1992_156# 0.4402f
C35 S VDD 0.11655f
C36 A a_1072_496# 0.01952f
C37 VSS VNW 0.00929f
C38 CI a_124_46# 0.27486f
C39 B a_3028_472# 0.00428f
C40 CI a_1072_156# 0.61579f
C41 a_952_112# a_3028_472# 0.00197f
C42 a_1992_156# a_1072_156# 0.00753f
C43 VNW a_124_46# 0.16913f
C44 a_512_496# a_1072_496# 0
C45 B a_1072_496# 0.02505f
C46 a_952_112# a_1072_496# 0.64312f
C47 VSS a_680_156# 0.00171f
C48 VDD a_3028_472# 0.00593f
C49 A CO 0.00492f
C50 A a_2012_472# 0.01748f
C51 A CI 0.19946f
C52 VSS a_124_46# 0.2636f
C53 A a_1992_156# 0.03757f
C54 VDD a_1072_496# 0.24649f
C55 VSS a_1072_156# 0.26696f
C56 a_680_156# a_124_46# 0.00316f
C57 CO a_3048_156# 0
C58 A VNW 0.5461f
C59 S a_1072_496# 0
C60 CO B 0.04604f
C61 a_1072_156# a_124_46# 0.0288f
C62 CO a_952_112# 0.09856f
C63 B a_2012_472# 0.02435f
C64 B CI 0.29069f
C65 a_952_112# a_2012_472# 0.7796f
C66 a_952_112# CI 2.35643f
C67 A VSS 0.29818f
C68 B a_1992_156# 0.03179f
C69 a_680_496# a_124_46# 0.00655f
C70 B VNW 1.60177f
C71 a_952_112# VNW 0.36494f
C72 VSS a_3048_156# 0.00154f
C73 CO VDD 0.1376f
C74 VDD a_2012_472# 0.26559f
C75 VDD CI 0.0464f
C76 A a_124_46# 0.55465f
C77 A a_1072_156# 0.03679f
C78 VDD VNW 0.53727f
C79 B VSS 0.05256f
C80 VSS a_952_112# 0.21744f
C81 S CI 0
C82 A a_680_496# 0
C83 VSS a_512_156# 0.00183f
C84 S VNW 0.03901f
C85 a_512_496# a_124_46# 0.00639f
C86 VSS VDD 0.01722f
C87 B a_124_46# 0.05484f
C88 a_952_112# a_124_46# 0.01486f
C89 B a_1072_156# 0.0302f
C90 a_952_112# a_1072_156# 0.00934f
C91 a_512_156# a_124_46# 0.00257f
C92 VSS VPW 1.20313f
C93 CO VPW 0.09048f
C94 CI VPW 0.42773f
C95 A VPW 1.99736f
C96 VDD VPW 0.74918f
C97 S VPW 0.10684f
C98 B VPW 0.73299f
C99 VNW VPW 6.01087f
C100 a_1992_156# VPW 0.03194f $ **FLOATING
C101 a_1072_156# VPW 0.03106f $ **FLOATING
C102 a_952_112# VPW 0.31991f $ **FLOATING
C103 a_124_46# VPW 0.21891f $ **FLOATING
.ends
