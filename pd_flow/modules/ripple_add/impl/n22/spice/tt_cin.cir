* ripple_add N=22 input capacitance, corner tt
.include /Users/samuelzhang/ttsetup/pdk/ciel/gf180mcu/versions/54435919abffb937387ec956209f9cf5fd2dfbee/gf180mcuD/libs.tech/ngspice/design.ngspice
.lib /Users/samuelzhang/ttsetup/pdk/ciel/gf180mcu/versions/54435919abffb937387ec956209f9cf5fd2dfbee/gf180mcuD/libs.tech/ngspice/sm141064.ngspice typical
.include ../pex/ripple_add_n22_pex.spice
.temp 25
.options method=gear reltol=1e-4 abstol=1e-13
VDD vpwr 0 3.3
X1 0 vpwr a_0 a_10 a_11 a_12 a_13 a_14 a_15 a_16 a_17 a_18 a_19 a_1 a_20 a_21 a_2 a_3 a_4 a_5 a_6 a_7 a_8 a_9 b_0 b_10 b_11 b_12 b_13 b_14 b_15 b_16 b_17 b_18 b_19 b_1 b_20 b_21 b_2 b_3 b_4 b_5 b_6 b_7 b_8 b_9 cin s_0 s_10 s_11 s_12 s_13 s_14 s_15 s_16 s_17 s_18 s_19 s_1 s_20 s_21 s_2 s_3 s_4 s_5 s_6 s_7 s_8 s_9 ripple_add
C_s_0 s_0 0 2e-14
C_s_1 s_1 0 2e-14
C_s_2 s_2 0 2e-14
C_s_3 s_3 0 2e-14
C_s_4 s_4 0 2e-14
C_s_5 s_5 0 2e-14
C_s_6 s_6 0 2e-14
C_s_7 s_7 0 2e-14
C_s_8 s_8 0 2e-14
C_s_9 s_9 0 2e-14
C_s_10 s_10 0 2e-14
C_s_11 s_11 0 2e-14
C_s_12 s_12 0 2e-14
C_s_13 s_13 0 2e-14
C_s_14 s_14 0 2e-14
C_s_15 s_15 0 2e-14
C_s_16 s_16 0 2e-14
C_s_17 s_17 0 2e-14
C_s_18 s_18 0 2e-14
C_s_19 s_19 0 2e-14
C_s_20 s_20 0 2e-14
C_s_21 s_21 0 2e-14
V_a_0 a_0 0 PWL(0.000000e+00 0.0000 2.000000e-09 0.0000 2.375000e-09 3.3000 8.000000e-09 3.3000 8.375000e-09 0.0000)
.meas tran qr_0 INTEG i(V_a_0) FROM=1.900000e-09 TO=7.900000e-09
.meas tran qf_0 INTEG i(V_a_0) FROM=7.900000e-09 TO=1.390000e-08
V_a_1 a_1 0 PWL(0.000000e+00 0.0000 1.400000e-08 0.0000 1.437500e-08 3.3000 2.000000e-08 3.3000 2.037500e-08 0.0000)
.meas tran qr_1 INTEG i(V_a_1) FROM=1.390000e-08 TO=1.990000e-08
.meas tran qf_1 INTEG i(V_a_1) FROM=1.990000e-08 TO=2.590000e-08
V_a_2 a_2 0 PWL(0.000000e+00 0.0000 2.600000e-08 0.0000 2.637500e-08 3.3000 3.200000e-08 3.3000 3.237500e-08 0.0000)
.meas tran qr_2 INTEG i(V_a_2) FROM=2.590000e-08 TO=3.190000e-08
.meas tran qf_2 INTEG i(V_a_2) FROM=3.190000e-08 TO=3.790000e-08
V_a_3 a_3 0 PWL(0.000000e+00 0.0000 3.800000e-08 0.0000 3.837500e-08 3.3000 4.400000e-08 3.3000 4.437500e-08 0.0000)
.meas tran qr_3 INTEG i(V_a_3) FROM=3.790000e-08 TO=4.390000e-08
.meas tran qf_3 INTEG i(V_a_3) FROM=4.390000e-08 TO=4.990000e-08
V_a_4 a_4 0 PWL(0.000000e+00 0.0000 5.000000e-08 0.0000 5.037500e-08 3.3000 5.600000e-08 3.3000 5.637500e-08 0.0000)
.meas tran qr_4 INTEG i(V_a_4) FROM=4.990000e-08 TO=5.590000e-08
.meas tran qf_4 INTEG i(V_a_4) FROM=5.590000e-08 TO=6.190000e-08
V_a_5 a_5 0 PWL(0.000000e+00 0.0000 6.200000e-08 0.0000 6.237500e-08 3.3000 6.800000e-08 3.3000 6.837500e-08 0.0000)
.meas tran qr_5 INTEG i(V_a_5) FROM=6.190000e-08 TO=6.790000e-08
.meas tran qf_5 INTEG i(V_a_5) FROM=6.790000e-08 TO=7.390000e-08
V_a_6 a_6 0 PWL(0.000000e+00 0.0000 7.400000e-08 0.0000 7.437500e-08 3.3000 8.000000e-08 3.3000 8.037500e-08 0.0000)
.meas tran qr_6 INTEG i(V_a_6) FROM=7.390000e-08 TO=7.990000e-08
.meas tran qf_6 INTEG i(V_a_6) FROM=7.990000e-08 TO=8.590000e-08
V_a_7 a_7 0 PWL(0.000000e+00 0.0000 8.600000e-08 0.0000 8.637500e-08 3.3000 9.200000e-08 3.3000 9.237500e-08 0.0000)
.meas tran qr_7 INTEG i(V_a_7) FROM=8.590000e-08 TO=9.190000e-08
.meas tran qf_7 INTEG i(V_a_7) FROM=9.190000e-08 TO=9.790000e-08
V_a_8 a_8 0 PWL(0.000000e+00 0.0000 9.800000e-08 0.0000 9.837500e-08 3.3000 1.040000e-07 3.3000 1.043750e-07 0.0000)
.meas tran qr_8 INTEG i(V_a_8) FROM=9.790000e-08 TO=1.039000e-07
.meas tran qf_8 INTEG i(V_a_8) FROM=1.039000e-07 TO=1.099000e-07
V_a_9 a_9 0 PWL(0.000000e+00 0.0000 1.100000e-07 0.0000 1.103750e-07 3.3000 1.160000e-07 3.3000 1.163750e-07 0.0000)
.meas tran qr_9 INTEG i(V_a_9) FROM=1.099000e-07 TO=1.159000e-07
.meas tran qf_9 INTEG i(V_a_9) FROM=1.159000e-07 TO=1.219000e-07
V_a_10 a_10 0 PWL(0.000000e+00 0.0000 1.220000e-07 0.0000 1.223750e-07 3.3000 1.280000e-07 3.3000 1.283750e-07 0.0000)
.meas tran qr_10 INTEG i(V_a_10) FROM=1.219000e-07 TO=1.279000e-07
.meas tran qf_10 INTEG i(V_a_10) FROM=1.279000e-07 TO=1.339000e-07
V_a_11 a_11 0 PWL(0.000000e+00 0.0000 1.340000e-07 0.0000 1.343750e-07 3.3000 1.400000e-07 3.3000 1.403750e-07 0.0000)
.meas tran qr_11 INTEG i(V_a_11) FROM=1.339000e-07 TO=1.399000e-07
.meas tran qf_11 INTEG i(V_a_11) FROM=1.399000e-07 TO=1.459000e-07
V_a_12 a_12 0 PWL(0.000000e+00 0.0000 1.460000e-07 0.0000 1.463750e-07 3.3000 1.520000e-07 3.3000 1.523750e-07 0.0000)
.meas tran qr_12 INTEG i(V_a_12) FROM=1.459000e-07 TO=1.519000e-07
.meas tran qf_12 INTEG i(V_a_12) FROM=1.519000e-07 TO=1.579000e-07
V_a_13 a_13 0 PWL(0.000000e+00 0.0000 1.580000e-07 0.0000 1.583750e-07 3.3000 1.640000e-07 3.3000 1.643750e-07 0.0000)
.meas tran qr_13 INTEG i(V_a_13) FROM=1.579000e-07 TO=1.639000e-07
.meas tran qf_13 INTEG i(V_a_13) FROM=1.639000e-07 TO=1.699000e-07
V_a_14 a_14 0 PWL(0.000000e+00 0.0000 1.700000e-07 0.0000 1.703750e-07 3.3000 1.760000e-07 3.3000 1.763750e-07 0.0000)
.meas tran qr_14 INTEG i(V_a_14) FROM=1.699000e-07 TO=1.759000e-07
.meas tran qf_14 INTEG i(V_a_14) FROM=1.759000e-07 TO=1.819000e-07
V_a_15 a_15 0 PWL(0.000000e+00 0.0000 1.820000e-07 0.0000 1.823750e-07 3.3000 1.880000e-07 3.3000 1.883750e-07 0.0000)
.meas tran qr_15 INTEG i(V_a_15) FROM=1.819000e-07 TO=1.879000e-07
.meas tran qf_15 INTEG i(V_a_15) FROM=1.879000e-07 TO=1.939000e-07
V_a_16 a_16 0 PWL(0.000000e+00 0.0000 1.940000e-07 0.0000 1.943750e-07 3.3000 2.000000e-07 3.3000 2.003750e-07 0.0000)
.meas tran qr_16 INTEG i(V_a_16) FROM=1.939000e-07 TO=1.999000e-07
.meas tran qf_16 INTEG i(V_a_16) FROM=1.999000e-07 TO=2.059000e-07
V_a_17 a_17 0 PWL(0.000000e+00 0.0000 2.060000e-07 0.0000 2.063750e-07 3.3000 2.120000e-07 3.3000 2.123750e-07 0.0000)
.meas tran qr_17 INTEG i(V_a_17) FROM=2.059000e-07 TO=2.119000e-07
.meas tran qf_17 INTEG i(V_a_17) FROM=2.119000e-07 TO=2.179000e-07
V_a_18 a_18 0 PWL(0.000000e+00 0.0000 2.180000e-07 0.0000 2.183750e-07 3.3000 2.240000e-07 3.3000 2.243750e-07 0.0000)
.meas tran qr_18 INTEG i(V_a_18) FROM=2.179000e-07 TO=2.239000e-07
.meas tran qf_18 INTEG i(V_a_18) FROM=2.239000e-07 TO=2.299000e-07
V_a_19 a_19 0 PWL(0.000000e+00 0.0000 2.300000e-07 0.0000 2.303750e-07 3.3000 2.360000e-07 3.3000 2.363750e-07 0.0000)
.meas tran qr_19 INTEG i(V_a_19) FROM=2.299000e-07 TO=2.359000e-07
.meas tran qf_19 INTEG i(V_a_19) FROM=2.359000e-07 TO=2.419000e-07
V_a_20 a_20 0 PWL(0.000000e+00 0.0000 2.420000e-07 0.0000 2.423750e-07 3.3000 2.480000e-07 3.3000 2.483750e-07 0.0000)
.meas tran qr_20 INTEG i(V_a_20) FROM=2.419000e-07 TO=2.479000e-07
.meas tran qf_20 INTEG i(V_a_20) FROM=2.479000e-07 TO=2.539000e-07
V_a_21 a_21 0 PWL(0.000000e+00 0.0000 2.540000e-07 0.0000 2.543750e-07 3.3000 2.600000e-07 3.3000 2.603750e-07 0.0000)
.meas tran qr_21 INTEG i(V_a_21) FROM=2.539000e-07 TO=2.599000e-07
.meas tran qf_21 INTEG i(V_a_21) FROM=2.599000e-07 TO=2.659000e-07
V_b_0 b_0 0 PWL(0.000000e+00 0.0000 2.660000e-07 0.0000 2.663750e-07 3.3000 2.720000e-07 3.3000 2.723750e-07 0.0000)
.meas tran qr_22 INTEG i(V_b_0) FROM=2.659000e-07 TO=2.719000e-07
.meas tran qf_22 INTEG i(V_b_0) FROM=2.719000e-07 TO=2.779000e-07
V_b_1 b_1 0 PWL(0.000000e+00 0.0000 2.780000e-07 0.0000 2.783750e-07 3.3000 2.840000e-07 3.3000 2.843750e-07 0.0000)
.meas tran qr_23 INTEG i(V_b_1) FROM=2.779000e-07 TO=2.839000e-07
.meas tran qf_23 INTEG i(V_b_1) FROM=2.839000e-07 TO=2.899000e-07
V_b_2 b_2 0 PWL(0.000000e+00 0.0000 2.900000e-07 0.0000 2.903750e-07 3.3000 2.960000e-07 3.3000 2.963750e-07 0.0000)
.meas tran qr_24 INTEG i(V_b_2) FROM=2.899000e-07 TO=2.959000e-07
.meas tran qf_24 INTEG i(V_b_2) FROM=2.959000e-07 TO=3.019000e-07
V_b_3 b_3 0 PWL(0.000000e+00 0.0000 3.020000e-07 0.0000 3.023750e-07 3.3000 3.080000e-07 3.3000 3.083750e-07 0.0000)
.meas tran qr_25 INTEG i(V_b_3) FROM=3.019000e-07 TO=3.079000e-07
.meas tran qf_25 INTEG i(V_b_3) FROM=3.079000e-07 TO=3.139000e-07
V_b_4 b_4 0 PWL(0.000000e+00 0.0000 3.140000e-07 0.0000 3.143750e-07 3.3000 3.200000e-07 3.3000 3.203750e-07 0.0000)
.meas tran qr_26 INTEG i(V_b_4) FROM=3.139000e-07 TO=3.199000e-07
.meas tran qf_26 INTEG i(V_b_4) FROM=3.199000e-07 TO=3.259000e-07
V_b_5 b_5 0 PWL(0.000000e+00 0.0000 3.260000e-07 0.0000 3.263750e-07 3.3000 3.320000e-07 3.3000 3.323750e-07 0.0000)
.meas tran qr_27 INTEG i(V_b_5) FROM=3.259000e-07 TO=3.319000e-07
.meas tran qf_27 INTEG i(V_b_5) FROM=3.319000e-07 TO=3.379000e-07
V_b_6 b_6 0 PWL(0.000000e+00 0.0000 3.380000e-07 0.0000 3.383750e-07 3.3000 3.440000e-07 3.3000 3.443750e-07 0.0000)
.meas tran qr_28 INTEG i(V_b_6) FROM=3.379000e-07 TO=3.439000e-07
.meas tran qf_28 INTEG i(V_b_6) FROM=3.439000e-07 TO=3.499000e-07
V_b_7 b_7 0 PWL(0.000000e+00 0.0000 3.500000e-07 0.0000 3.503750e-07 3.3000 3.560000e-07 3.3000 3.563750e-07 0.0000)
.meas tran qr_29 INTEG i(V_b_7) FROM=3.499000e-07 TO=3.559000e-07
.meas tran qf_29 INTEG i(V_b_7) FROM=3.559000e-07 TO=3.619000e-07
V_b_8 b_8 0 PWL(0.000000e+00 0.0000 3.620000e-07 0.0000 3.623750e-07 3.3000 3.680000e-07 3.3000 3.683750e-07 0.0000)
.meas tran qr_30 INTEG i(V_b_8) FROM=3.619000e-07 TO=3.679000e-07
.meas tran qf_30 INTEG i(V_b_8) FROM=3.679000e-07 TO=3.739000e-07
V_b_9 b_9 0 PWL(0.000000e+00 0.0000 3.740000e-07 0.0000 3.743750e-07 3.3000 3.800000e-07 3.3000 3.803750e-07 0.0000)
.meas tran qr_31 INTEG i(V_b_9) FROM=3.739000e-07 TO=3.799000e-07
.meas tran qf_31 INTEG i(V_b_9) FROM=3.799000e-07 TO=3.859000e-07
V_b_10 b_10 0 PWL(0.000000e+00 0.0000 3.860000e-07 0.0000 3.863750e-07 3.3000 3.920000e-07 3.3000 3.923750e-07 0.0000)
.meas tran qr_32 INTEG i(V_b_10) FROM=3.859000e-07 TO=3.919000e-07
.meas tran qf_32 INTEG i(V_b_10) FROM=3.919000e-07 TO=3.979000e-07
V_b_11 b_11 0 PWL(0.000000e+00 0.0000 3.980000e-07 0.0000 3.983750e-07 3.3000 4.040000e-07 3.3000 4.043750e-07 0.0000)
.meas tran qr_33 INTEG i(V_b_11) FROM=3.979000e-07 TO=4.039000e-07
.meas tran qf_33 INTEG i(V_b_11) FROM=4.039000e-07 TO=4.099000e-07
V_b_12 b_12 0 PWL(0.000000e+00 0.0000 4.100000e-07 0.0000 4.103750e-07 3.3000 4.160000e-07 3.3000 4.163750e-07 0.0000)
.meas tran qr_34 INTEG i(V_b_12) FROM=4.099000e-07 TO=4.159000e-07
.meas tran qf_34 INTEG i(V_b_12) FROM=4.159000e-07 TO=4.219000e-07
V_b_13 b_13 0 PWL(0.000000e+00 0.0000 4.220000e-07 0.0000 4.223750e-07 3.3000 4.280000e-07 3.3000 4.283750e-07 0.0000)
.meas tran qr_35 INTEG i(V_b_13) FROM=4.219000e-07 TO=4.279000e-07
.meas tran qf_35 INTEG i(V_b_13) FROM=4.279000e-07 TO=4.339000e-07
V_b_14 b_14 0 PWL(0.000000e+00 0.0000 4.340000e-07 0.0000 4.343750e-07 3.3000 4.400000e-07 3.3000 4.403750e-07 0.0000)
.meas tran qr_36 INTEG i(V_b_14) FROM=4.339000e-07 TO=4.399000e-07
.meas tran qf_36 INTEG i(V_b_14) FROM=4.399000e-07 TO=4.459000e-07
V_b_15 b_15 0 PWL(0.000000e+00 0.0000 4.460000e-07 0.0000 4.463750e-07 3.3000 4.520000e-07 3.3000 4.523750e-07 0.0000)
.meas tran qr_37 INTEG i(V_b_15) FROM=4.459000e-07 TO=4.519000e-07
.meas tran qf_37 INTEG i(V_b_15) FROM=4.519000e-07 TO=4.579000e-07
V_b_16 b_16 0 PWL(0.000000e+00 0.0000 4.580000e-07 0.0000 4.583750e-07 3.3000 4.640000e-07 3.3000 4.643750e-07 0.0000)
.meas tran qr_38 INTEG i(V_b_16) FROM=4.579000e-07 TO=4.639000e-07
.meas tran qf_38 INTEG i(V_b_16) FROM=4.639000e-07 TO=4.699000e-07
V_b_17 b_17 0 PWL(0.000000e+00 0.0000 4.700000e-07 0.0000 4.703750e-07 3.3000 4.760000e-07 3.3000 4.763750e-07 0.0000)
.meas tran qr_39 INTEG i(V_b_17) FROM=4.699000e-07 TO=4.759000e-07
.meas tran qf_39 INTEG i(V_b_17) FROM=4.759000e-07 TO=4.819000e-07
V_b_18 b_18 0 PWL(0.000000e+00 0.0000 4.820000e-07 0.0000 4.823750e-07 3.3000 4.880000e-07 3.3000 4.883750e-07 0.0000)
.meas tran qr_40 INTEG i(V_b_18) FROM=4.819000e-07 TO=4.879000e-07
.meas tran qf_40 INTEG i(V_b_18) FROM=4.879000e-07 TO=4.939000e-07
V_b_19 b_19 0 PWL(0.000000e+00 0.0000 4.940000e-07 0.0000 4.943750e-07 3.3000 5.000000e-07 3.3000 5.003750e-07 0.0000)
.meas tran qr_41 INTEG i(V_b_19) FROM=4.939000e-07 TO=4.999000e-07
.meas tran qf_41 INTEG i(V_b_19) FROM=4.999000e-07 TO=5.059000e-07
V_b_20 b_20 0 PWL(0.000000e+00 0.0000 5.060000e-07 0.0000 5.063750e-07 3.3000 5.120000e-07 3.3000 5.123750e-07 0.0000)
.meas tran qr_42 INTEG i(V_b_20) FROM=5.059000e-07 TO=5.119000e-07
.meas tran qf_42 INTEG i(V_b_20) FROM=5.119000e-07 TO=5.179000e-07
V_b_21 b_21 0 PWL(0.000000e+00 0.0000 5.180000e-07 0.0000 5.183750e-07 3.3000 5.240000e-07 3.3000 5.243750e-07 0.0000)
.meas tran qr_43 INTEG i(V_b_21) FROM=5.179000e-07 TO=5.239000e-07
.meas tran qf_43 INTEG i(V_b_21) FROM=5.239000e-07 TO=5.299000e-07
V_cin cin 0 PWL(0.000000e+00 0.0000 5.300000e-07 0.0000 5.303750e-07 3.3000 5.360000e-07 3.3000 5.363750e-07 0.0000)
.meas tran qr_44 INTEG i(V_cin) FROM=5.299000e-07 TO=5.359000e-07
.meas tran qf_44 INTEG i(V_cin) FROM=5.359000e-07 TO=5.419000e-07
.tran 10p 5.420000e-07
.end
