* ripple_add N=22 functional, corner tt
.include /Users/samuelzhang/ttsetup/pdk/ciel/gf180mcu/versions/54435919abffb937387ec956209f9cf5fd2dfbee/gf180mcuD/libs.tech/ngspice/design.ngspice
.lib /Users/samuelzhang/ttsetup/pdk/ciel/gf180mcu/versions/54435919abffb937387ec956209f9cf5fd2dfbee/gf180mcuD/libs.tech/ngspice/sm141064.ngspice typical
.include ../pex/ripple_add_n22_pex.spice
.temp 25
.options method=gear reltol=1e-4 abstol=1e-13
VDD vpwr 0 3.3
X1 0 vpwr a_0 a_10 a_11 a_12 a_13 a_14 a_15 a_16 a_17 a_18 a_19 a_1 a_20 a_21 a_2 a_3 a_4 a_5 a_6 a_7 a_8 a_9 b_0 b_10 b_11 b_12 b_13 b_14 b_15 b_16 b_17 b_18 b_19 b_1 b_20 b_21 b_2 b_3 b_4 b_5 b_6 b_7 b_8 b_9 cin s_0 s_10 s_11 s_12 s_13 s_14 s_15 s_16 s_17 s_18 s_19 s_1 s_20 s_21 s_2 s_3 s_4 s_5 s_6 s_7 s_8 s_9 ripple_add
C_s_0 s_0 0 2e-14
C_s_1 s_1 0 2e-14
C_s_2 s_2 0 2e-14
C_s_3 s_3 0 2e-14
C_s_4 s_4 0 2e-14
C_s_5 s_5 0 2e-14
C_s_6 s_6 0 2e-14
C_s_7 s_7 0 2e-14
C_s_8 s_8 0 2e-14
C_s_9 s_9 0 2e-14
C_s_10 s_10 0 2e-14
C_s_11 s_11 0 2e-14
C_s_12 s_12 0 2e-14
C_s_13 s_13 0 2e-14
C_s_14 s_14 0 2e-14
C_s_15 s_15 0 2e-14
C_s_16 s_16 0 2e-14
C_s_17 s_17 0 2e-14
C_s_18 s_18 0 2e-14
C_s_19 s_19 0 2e-14
C_s_20 s_20 0 2e-14
C_s_21 s_21 0 2e-14
V_a_0 a_0 0 PWL(0.000000e+00 0.0000 4.200000e-08 0.0000 4.237500e-08 3.3000 1.620000e-07 3.3000 1.623750e-07 0.0000 2.020000e-07 0.0000 2.023750e-07 3.3000 2.820000e-07 3.3000 2.823750e-07 0.0000 3.620000e-07 0.0000 3.623750e-07 3.3000 4.020000e-07 3.3000 4.023750e-07 0.0000 4.820000e-07 0.0000 4.823750e-07 3.3000 5.220000e-07 3.3000 5.223750e-07 0.0000 5.620000e-07 0.0000 5.623750e-07 3.3000 6.820000e-07 3.3000 6.823750e-07 0.0000)
V_a_1 a_1 0 PWL(0.000000e+00 0.0000 4.200000e-08 0.0000 4.237500e-08 3.3000 1.620000e-07 3.3000 1.623750e-07 0.0000 2.020000e-07 0.0000 2.023750e-07 3.3000 2.420000e-07 3.3000 2.423750e-07 0.0000 3.220000e-07 0.0000 3.223750e-07 3.3000 3.620000e-07 3.3000 3.623750e-07 0.0000 4.420000e-07 0.0000 4.423750e-07 3.3000 4.820000e-07 3.3000 4.823750e-07 0.0000 5.220000e-07 0.0000 5.223750e-07 3.3000 5.620000e-07 3.3000 5.623750e-07 0.0000 6.820000e-07 0.0000 6.823750e-07 3.3000 7.220000e-07 3.3000 7.223750e-07 0.0000)
V_a_2 a_2 0 PWL(0.000000e+00 0.0000 4.200000e-08 0.0000 4.237500e-08 3.3000 1.620000e-07 3.3000 1.623750e-07 0.0000 2.020000e-07 0.0000 2.023750e-07 3.3000 2.420000e-07 3.3000 2.423750e-07 0.0000 3.620000e-07 0.0000 3.623750e-07 3.3000 4.020000e-07 3.3000 4.023750e-07 0.0000 4.820000e-07 0.0000 4.823750e-07 3.3000 5.220000e-07 3.3000 5.223750e-07 0.0000 6.020000e-07 0.0000 6.023750e-07 3.3000)
V_a_3 a_3 0 PWL(0.000000e+00 0.0000 4.200000e-08 0.0000 4.237500e-08 3.3000 1.620000e-07 3.3000 1.623750e-07 0.0000 2.020000e-07 0.0000 2.023750e-07 3.3000 2.420000e-07 3.3000 2.423750e-07 0.0000 2.820000e-07 0.0000 2.823750e-07 3.3000 3.620000e-07 3.3000 3.623750e-07 0.0000 4.420000e-07 0.0000 4.423750e-07 3.3000 5.220000e-07 3.3000 5.223750e-07 0.0000 6.020000e-07 0.0000 6.023750e-07 3.3000 6.420000e-07 3.3000 6.423750e-07 0.0000 6.820000e-07 0.0000 6.823750e-07 3.3000 7.220000e-07 3.3000 7.223750e-07 0.0000)
V_a_4 a_4 0 PWL(0.000000e+00 0.0000 4.200000e-08 0.0000 4.237500e-08 3.3000 1.620000e-07 3.3000 1.623750e-07 0.0000 2.020000e-07 0.0000 2.023750e-07 3.3000 2.420000e-07 3.3000 2.423750e-07 0.0000 5.620000e-07 0.0000 5.623750e-07 3.3000 6.420000e-07 3.3000 6.423750e-07 0.0000 6.820000e-07 0.0000 6.823750e-07 3.3000)
V_a_5 a_5 0 PWL(0.000000e+00 0.0000 4.200000e-08 0.0000 4.237500e-08 3.3000 1.620000e-07 3.3000 1.623750e-07 0.0000 2.020000e-07 0.0000 2.023750e-07 3.3000 2.420000e-07 3.3000 2.423750e-07 0.0000 2.820000e-07 0.0000 2.823750e-07 3.3000 3.620000e-07 3.3000 3.623750e-07 0.0000 4.420000e-07 0.0000 4.423750e-07 3.3000 4.820000e-07 3.3000 4.823750e-07 0.0000 6.020000e-07 0.0000 6.023750e-07 3.3000 6.420000e-07 3.3000 6.423750e-07 0.0000)
V_a_6 a_6 0 PWL(0.000000e+00 0.0000 4.200000e-08 0.0000 4.237500e-08 3.3000 1.620000e-07 3.3000 1.623750e-07 0.0000 2.020000e-07 0.0000 2.023750e-07 3.3000 2.420000e-07 3.3000 2.423750e-07 0.0000 2.820000e-07 0.0000 2.823750e-07 3.3000 3.220000e-07 3.3000 3.223750e-07 0.0000 4.820000e-07 0.0000 4.823750e-07 3.3000 5.220000e-07 3.3000 5.223750e-07 0.0000 5.620000e-07 0.0000 5.623750e-07 3.3000 6.420000e-07 3.3000 6.423750e-07 0.0000 6.820000e-07 0.0000 6.823750e-07 3.3000)
V_a_7 a_7 0 PWL(0.000000e+00 0.0000 4.200000e-08 0.0000 4.237500e-08 3.3000 1.620000e-07 3.3000 1.623750e-07 0.0000 2.020000e-07 0.0000 2.023750e-07 3.3000 2.420000e-07 3.3000 2.423750e-07 0.0000 2.820000e-07 0.0000 2.823750e-07 3.3000 3.620000e-07 3.3000 3.623750e-07 0.0000 5.220000e-07 0.0000 5.223750e-07 3.3000 7.220000e-07 3.3000 7.223750e-07 0.0000)
V_a_8 a_8 0 PWL(0.000000e+00 0.0000 4.200000e-08 0.0000 4.237500e-08 3.3000 1.620000e-07 3.3000 1.623750e-07 0.0000 2.020000e-07 0.0000 2.023750e-07 3.3000 2.420000e-07 3.3000 2.423750e-07 0.0000 2.820000e-07 0.0000 2.823750e-07 3.3000 3.220000e-07 3.3000 3.223750e-07 0.0000 4.420000e-07 0.0000 4.423750e-07 3.3000 4.820000e-07 3.3000 4.823750e-07 0.0000 5.220000e-07 0.0000 5.223750e-07 3.3000 5.620000e-07 3.3000 5.623750e-07 0.0000 6.420000e-07 0.0000 6.423750e-07 3.3000 6.820000e-07 3.3000 6.823750e-07 0.0000 7.220000e-07 0.0000 7.223750e-07 3.3000)
V_a_9 a_9 0 PWL(0.000000e+00 0.0000 4.200000e-08 0.0000 4.237500e-08 3.3000 1.620000e-07 3.3000 1.623750e-07 0.0000 2.020000e-07 0.0000 2.023750e-07 3.3000 2.420000e-07 3.3000 2.423750e-07 0.0000 2.820000e-07 0.0000 2.823750e-07 3.3000 3.620000e-07 3.3000 3.623750e-07 0.0000 4.820000e-07 0.0000 4.823750e-07 3.3000 5.620000e-07 3.3000 5.623750e-07 0.0000 6.020000e-07 0.0000 6.023750e-07 3.3000 6.420000e-07 3.3000 6.423750e-07 0.0000 7.220000e-07 0.0000 7.223750e-07 3.3000)
V_a_10 a_10 0 PWL(0.000000e+00 0.0000 4.200000e-08 0.0000 4.237500e-08 3.3000 1.620000e-07 3.3000 1.623750e-07 0.0000 2.020000e-07 0.0000 2.023750e-07 3.3000 2.420000e-07 3.3000 2.423750e-07 0.0000 4.820000e-07 0.0000 4.823750e-07 3.3000 5.620000e-07 3.3000 5.623750e-07 0.0000 6.020000e-07 0.0000 6.023750e-07 3.3000 6.420000e-07 3.3000 6.423750e-07 0.0000 6.820000e-07 0.0000 6.823750e-07 3.3000)
V_a_11 a_11 0 PWL(0.000000e+00 0.0000 4.200000e-08 0.0000 4.237500e-08 3.3000 1.620000e-07 3.3000 1.623750e-07 0.0000 2.020000e-07 0.0000 2.023750e-07 3.3000 2.420000e-07 3.3000 2.423750e-07 0.0000 3.220000e-07 0.0000 3.223750e-07 3.3000 3.620000e-07 3.3000 3.623750e-07 0.0000 4.820000e-07 0.0000 4.823750e-07 3.3000 6.020000e-07 3.3000 6.023750e-07 0.0000 6.420000e-07 0.0000 6.423750e-07 3.3000 6.820000e-07 3.3000 6.823750e-07 0.0000)
V_a_12 a_12 0 PWL(0.000000e+00 0.0000 4.200000e-08 0.0000 4.237500e-08 3.3000 1.620000e-07 3.3000 1.623750e-07 0.0000 2.020000e-07 0.0000 2.023750e-07 3.3000 2.420000e-07 3.3000 2.423750e-07 0.0000 6.020000e-07 0.0000 6.023750e-07 3.3000 6.420000e-07 3.3000 6.423750e-07 0.0000 7.220000e-07 0.0000 7.223750e-07 3.3000)
V_a_13 a_13 0 PWL(0.000000e+00 0.0000 4.200000e-08 0.0000 4.237500e-08 3.3000 1.620000e-07 3.3000 1.623750e-07 0.0000 2.020000e-07 0.0000 2.023750e-07 3.3000 2.420000e-07 3.3000 2.423750e-07 0.0000 3.220000e-07 0.0000 3.223750e-07 3.3000 3.620000e-07 3.3000 3.623750e-07 0.0000 4.420000e-07 0.0000 4.423750e-07 3.3000 5.620000e-07 3.3000 5.623750e-07 0.0000 6.020000e-07 0.0000 6.023750e-07 3.3000 6.820000e-07 3.3000 6.823750e-07 0.0000 7.220000e-07 0.0000 7.223750e-07 3.3000)
V_a_14 a_14 0 PWL(0.000000e+00 0.0000 4.200000e-08 0.0000 4.237500e-08 3.3000 1.620000e-07 3.3000 1.623750e-07 0.0000 2.020000e-07 0.0000 2.023750e-07 3.3000 2.420000e-07 3.3000 2.423750e-07 0.0000 4.420000e-07 0.0000 4.423750e-07 3.3000 5.220000e-07 3.3000 5.223750e-07 0.0000 5.620000e-07 0.0000 5.623750e-07 3.3000 6.420000e-07 3.3000 6.423750e-07 0.0000 6.820000e-07 0.0000 6.823750e-07 3.3000 7.220000e-07 3.3000 7.223750e-07 0.0000)
V_a_15 a_15 0 PWL(0.000000e+00 0.0000 4.200000e-08 0.0000 4.237500e-08 3.3000 1.620000e-07 3.3000 1.623750e-07 0.0000 2.020000e-07 0.0000 2.023750e-07 3.3000 2.420000e-07 3.3000 2.423750e-07 0.0000 3.220000e-07 0.0000 3.223750e-07 3.3000 3.620000e-07 3.3000 3.623750e-07 0.0000 4.820000e-07 0.0000 4.823750e-07 3.3000 5.220000e-07 3.3000 5.223750e-07 0.0000 5.620000e-07 0.0000 5.623750e-07 3.3000 6.020000e-07 3.3000 6.023750e-07 0.0000 6.420000e-07 0.0000 6.423750e-07 3.3000 7.220000e-07 3.3000 7.223750e-07 0.0000)
V_a_16 a_16 0 PWL(0.000000e+00 0.0000 4.200000e-08 0.0000 4.237500e-08 3.3000 1.620000e-07 3.3000 1.623750e-07 0.0000 2.020000e-07 0.0000 2.023750e-07 3.3000 2.420000e-07 3.3000 2.423750e-07 0.0000 4.820000e-07 0.0000 4.823750e-07 3.3000 5.620000e-07 3.3000 5.623750e-07 0.0000 6.820000e-07 0.0000 6.823750e-07 3.3000 7.220000e-07 3.3000 7.223750e-07 0.0000)
V_a_17 a_17 0 PWL(0.000000e+00 0.0000 4.200000e-08 0.0000 4.237500e-08 3.3000 1.620000e-07 3.3000 1.623750e-07 0.0000 2.020000e-07 0.0000 2.023750e-07 3.3000 2.420000e-07 3.3000 2.423750e-07 0.0000 3.220000e-07 0.0000 3.223750e-07 3.3000 3.620000e-07 3.3000 3.623750e-07 0.0000 4.420000e-07 0.0000 4.423750e-07 3.3000 5.220000e-07 3.3000 5.223750e-07 0.0000 6.420000e-07 0.0000 6.423750e-07 3.3000 7.220000e-07 3.3000 7.223750e-07 0.0000)
V_a_18 a_18 0 PWL(0.000000e+00 0.0000 4.200000e-08 0.0000 4.237500e-08 3.3000 1.620000e-07 3.3000 1.623750e-07 0.0000 2.020000e-07 0.0000 2.023750e-07 3.3000 2.420000e-07 3.3000 2.423750e-07 0.0000 4.420000e-07 0.0000 4.423750e-07 3.3000 6.020000e-07 3.3000 6.023750e-07 0.0000 6.420000e-07 0.0000 6.423750e-07 3.3000 7.220000e-07 3.3000 7.223750e-07 0.0000)
V_a_19 a_19 0 PWL(0.000000e+00 0.0000 4.200000e-08 0.0000 4.237500e-08 3.3000 1.620000e-07 3.3000 1.623750e-07 0.0000 2.020000e-07 0.0000 2.023750e-07 3.3000 2.420000e-07 3.3000 2.423750e-07 0.0000 3.220000e-07 0.0000 3.223750e-07 3.3000 3.620000e-07 3.3000 3.623750e-07 0.0000 4.420000e-07 0.0000 4.423750e-07 3.3000 4.820000e-07 3.3000 4.823750e-07 0.0000 6.020000e-07 0.0000 6.023750e-07 3.3000 6.420000e-07 3.3000 6.423750e-07 0.0000 6.820000e-07 0.0000 6.823750e-07 3.3000)
V_a_20 a_20 0 PWL(0.000000e+00 0.0000 4.200000e-08 0.0000 4.237500e-08 3.3000 1.620000e-07 3.3000 1.623750e-07 0.0000 2.020000e-07 0.0000 2.023750e-07 3.3000 2.420000e-07 3.3000 2.423750e-07 0.0000 4.420000e-07 0.0000 4.423750e-07 3.3000 4.820000e-07 3.3000 4.823750e-07 0.0000 5.620000e-07 0.0000 5.623750e-07 3.3000 6.020000e-07 3.3000 6.023750e-07 0.0000)
V_a_21 a_21 0 PWL(0.000000e+00 0.0000 4.200000e-08 0.0000 4.237500e-08 3.3000 1.620000e-07 3.3000 1.623750e-07 0.0000 2.020000e-07 0.0000 2.023750e-07 3.3000 2.420000e-07 3.3000 2.423750e-07 0.0000 3.220000e-07 0.0000 3.223750e-07 3.3000 3.620000e-07 3.3000 3.623750e-07 0.0000 4.820000e-07 0.0000 4.823750e-07 3.3000 5.220000e-07 3.3000 5.223750e-07 0.0000 6.020000e-07 0.0000 6.023750e-07 3.3000 6.420000e-07 3.3000 6.423750e-07 0.0000)
V_b_0 b_0 0 PWL(0.000000e+00 0.0000 1.620000e-07 0.0000 1.623750e-07 3.3000 3.220000e-07 3.3000 3.223750e-07 0.0000 5.220000e-07 0.0000 5.223750e-07 3.3000 7.220000e-07 3.3000 7.223750e-07 0.0000)
V_b_1 b_1 0 PWL(0.000000e+00 0.0000 1.620000e-07 0.0000 1.623750e-07 3.3000 2.820000e-07 3.3000 2.823750e-07 0.0000 3.220000e-07 0.0000 3.223750e-07 3.3000 4.420000e-07 3.3000 4.423750e-07 0.0000 4.820000e-07 0.0000 4.823750e-07 3.3000 6.420000e-07 3.3000 6.423750e-07 0.0000)
V_b_2 b_2 0 PWL(0.000000e+00 0.0000 1.620000e-07 0.0000 1.623750e-07 3.3000 3.220000e-07 3.3000 3.223750e-07 0.0000 4.020000e-07 0.0000 4.023750e-07 3.3000 5.620000e-07 3.3000 5.623750e-07 0.0000 6.820000e-07 0.0000 6.823750e-07 3.3000 7.220000e-07 3.3000 7.223750e-07 0.0000)
V_b_3 b_3 0 PWL(0.000000e+00 0.0000 1.620000e-07 0.0000 1.623750e-07 3.3000 4.820000e-07 3.3000 4.823750e-07 0.0000 5.620000e-07 0.0000 5.623750e-07 3.3000 6.820000e-07 3.3000 6.823750e-07 0.0000)
V_b_4 b_4 0 PWL(0.000000e+00 0.0000 1.620000e-07 0.0000 1.623750e-07 3.3000 2.820000e-07 3.3000 2.823750e-07 0.0000 3.620000e-07 0.0000 3.623750e-07 3.3000 5.220000e-07 3.3000 5.223750e-07 0.0000 5.620000e-07 0.0000 5.623750e-07 3.3000 6.020000e-07 3.3000 6.023750e-07 0.0000)
V_b_5 b_5 0 PWL(0.000000e+00 0.0000 1.620000e-07 0.0000 1.623750e-07 3.3000 4.420000e-07 3.3000 4.423750e-07 0.0000 4.820000e-07 0.0000 4.823750e-07 3.3000 5.620000e-07 3.3000 5.623750e-07 0.0000 6.020000e-07 0.0000 6.023750e-07 3.3000 6.420000e-07 3.3000 6.423750e-07 0.0000 7.220000e-07 0.0000 7.223750e-07 3.3000)
V_b_6 b_6 0 PWL(0.000000e+00 0.0000 1.620000e-07 0.0000 1.623750e-07 3.3000 2.820000e-07 3.3000 2.823750e-07 0.0000 3.620000e-07 0.0000 3.623750e-07 3.3000 4.420000e-07 3.3000 4.423750e-07 0.0000 6.020000e-07 0.0000 6.023750e-07 3.3000 6.820000e-07 3.3000 6.823750e-07 0.0000)
V_b_7 b_7 0 PWL(0.000000e+00 0.0000 1.620000e-07 0.0000 1.623750e-07 3.3000 2.820000e-07 3.3000 2.823750e-07 0.0000 3.220000e-07 0.0000 3.223750e-07 3.3000 5.220000e-07 3.3000 5.223750e-07 0.0000 5.620000e-07 0.0000 5.623750e-07 3.3000 6.020000e-07 3.3000 6.023750e-07 0.0000 6.420000e-07 0.0000 6.423750e-07 3.3000)
V_b_8 b_8 0 PWL(0.000000e+00 0.0000 1.620000e-07 0.0000 1.623750e-07 3.3000 3.220000e-07 3.3000 3.223750e-07 0.0000 3.620000e-07 0.0000 3.623750e-07 3.3000 4.420000e-07 3.3000 4.423750e-07 0.0000 5.220000e-07 0.0000 5.223750e-07 3.3000 6.020000e-07 3.3000 6.023750e-07 0.0000)
V_b_9 b_9 0 PWL(0.000000e+00 0.0000 1.620000e-07 0.0000 1.623750e-07 3.3000 4.420000e-07 3.3000 4.423750e-07 0.0000 5.620000e-07 0.0000 5.623750e-07 3.3000 6.020000e-07 3.3000 6.023750e-07 0.0000 6.420000e-07 0.0000 6.423750e-07 3.3000 7.220000e-07 3.3000 7.223750e-07 0.0000)
V_b_10 b_10 0 PWL(0.000000e+00 0.0000 1.620000e-07 0.0000 1.623750e-07 3.3000 2.820000e-07 3.3000 2.823750e-07 0.0000 3.620000e-07 0.0000 3.623750e-07 3.3000 4.420000e-07 3.3000 4.423750e-07 0.0000 4.820000e-07 0.0000 4.823750e-07 3.3000 5.620000e-07 3.3000 5.623750e-07 0.0000 6.420000e-07 0.0000 6.423750e-07 3.3000)
V_b_11 b_11 0 PWL(0.000000e+00 0.0000 1.620000e-07 0.0000 1.623750e-07 3.3000 4.820000e-07 3.3000 4.823750e-07 0.0000 5.620000e-07 0.0000 5.623750e-07 3.3000)
V_b_12 b_12 0 PWL(0.000000e+00 0.0000 1.620000e-07 0.0000 1.623750e-07 3.3000 3.220000e-07 3.3000 3.223750e-07 0.0000 3.620000e-07 0.0000 3.623750e-07 3.3000 5.220000e-07 3.3000 5.223750e-07 0.0000 6.020000e-07 0.0000 6.023750e-07 3.3000 6.820000e-07 3.3000 6.823750e-07 0.0000)
V_b_13 b_13 0 PWL(0.000000e+00 0.0000 1.620000e-07 0.0000 1.623750e-07 3.3000 5.220000e-07 3.3000 5.223750e-07 0.0000 5.620000e-07 0.0000 5.623750e-07 3.3000 6.020000e-07 3.3000 6.023750e-07 0.0000)
V_b_14 b_14 0 PWL(0.000000e+00 0.0000 1.620000e-07 0.0000 1.623750e-07 3.3000 3.220000e-07 3.3000 3.223750e-07 0.0000 3.620000e-07 0.0000 3.623750e-07 3.3000 6.020000e-07 3.3000 6.023750e-07 0.0000 6.820000e-07 0.0000 6.823750e-07 3.3000)
V_b_15 b_15 0 PWL(0.000000e+00 0.0000 1.620000e-07 0.0000 1.623750e-07 3.3000 4.420000e-07 3.3000 4.423750e-07 0.0000 4.820000e-07 0.0000 4.823750e-07 3.3000 6.020000e-07 3.3000 6.023750e-07 0.0000 6.820000e-07 0.0000 6.823750e-07 3.3000 7.220000e-07 3.3000 7.223750e-07 0.0000)
V_b_16 b_16 0 PWL(0.000000e+00 0.0000 1.620000e-07 0.0000 1.623750e-07 3.3000 3.220000e-07 3.3000 3.223750e-07 0.0000 3.620000e-07 0.0000 3.623750e-07 3.3000 4.420000e-07 3.3000 4.423750e-07 0.0000)
V_b_17 b_17 0 PWL(0.000000e+00 0.0000 1.620000e-07 0.0000 1.623750e-07 3.3000 4.420000e-07 3.3000 4.423750e-07 0.0000 4.820000e-07 0.0000 4.823750e-07 3.3000 5.620000e-07 3.3000 5.623750e-07 0.0000 6.420000e-07 0.0000 6.423750e-07 3.3000)
V_b_18 b_18 0 PWL(0.000000e+00 0.0000 1.620000e-07 0.0000 1.623750e-07 3.3000 3.220000e-07 3.3000 3.223750e-07 0.0000 3.620000e-07 0.0000 3.623750e-07 3.3000 4.820000e-07 3.3000 4.823750e-07 0.0000 5.220000e-07 0.0000 5.223750e-07 3.3000 5.620000e-07 3.3000 5.623750e-07 0.0000)
V_b_19 b_19 0 PWL(0.000000e+00 0.0000 1.620000e-07 0.0000 1.623750e-07 3.3000 5.220000e-07 3.3000 5.223750e-07 0.0000 5.620000e-07 0.0000 5.623750e-07 3.3000 6.820000e-07 3.3000 6.823750e-07 0.0000)
V_b_20 b_20 0 PWL(0.000000e+00 0.0000 1.620000e-07 0.0000 1.623750e-07 3.3000 3.220000e-07 3.3000 3.223750e-07 0.0000 3.620000e-07 0.0000 3.623750e-07 3.3000 4.820000e-07 3.3000 4.823750e-07 0.0000 5.220000e-07 0.0000 5.223750e-07 3.3000 5.620000e-07 3.3000 5.623750e-07 0.0000 6.420000e-07 0.0000 6.423750e-07 3.3000 6.820000e-07 3.3000 6.823750e-07 0.0000)
V_b_21 b_21 0 PWL(0.000000e+00 0.0000 1.620000e-07 0.0000 1.623750e-07 3.3000 4.420000e-07 3.3000 4.423750e-07 0.0000 4.820000e-07 0.0000 4.823750e-07 3.3000 6.420000e-07 3.3000 6.423750e-07 0.0000 6.820000e-07 0.0000 6.823750e-07 3.3000)
V_cin cin 0 PWL(0.000000e+00 0.0000 8.200000e-08 0.0000 8.237500e-08 3.3000 1.220000e-07 3.3000 1.223750e-07 0.0000 1.620000e-07 0.0000 1.623750e-07 3.3000 2.420000e-07 3.3000 2.423750e-07 0.0000 2.820000e-07 0.0000 2.823750e-07 3.3000 4.420000e-07 3.3000 4.423750e-07 0.0000 4.820000e-07 0.0000 4.823750e-07 3.3000 5.220000e-07 3.3000 5.223750e-07 0.0000 6.820000e-07 0.0000 6.823750e-07 3.3000)
.meas tran v0_s0 FIND v(s_0) AT=4.150000e-08
.meas tran v0_s1 FIND v(s_1) AT=4.150000e-08
.meas tran v0_s2 FIND v(s_2) AT=4.150000e-08
.meas tran v0_s3 FIND v(s_3) AT=4.150000e-08
.meas tran v0_s4 FIND v(s_4) AT=4.150000e-08
.meas tran v0_s5 FIND v(s_5) AT=4.150000e-08
.meas tran v0_s6 FIND v(s_6) AT=4.150000e-08
.meas tran v0_s7 FIND v(s_7) AT=4.150000e-08
.meas tran v0_s8 FIND v(s_8) AT=4.150000e-08
.meas tran v0_s9 FIND v(s_9) AT=4.150000e-08
.meas tran v0_s10 FIND v(s_10) AT=4.150000e-08
.meas tran v0_s11 FIND v(s_11) AT=4.150000e-08
.meas tran v0_s12 FIND v(s_12) AT=4.150000e-08
.meas tran v0_s13 FIND v(s_13) AT=4.150000e-08
.meas tran v0_s14 FIND v(s_14) AT=4.150000e-08
.meas tran v0_s15 FIND v(s_15) AT=4.150000e-08
.meas tran v0_s16 FIND v(s_16) AT=4.150000e-08
.meas tran v0_s17 FIND v(s_17) AT=4.150000e-08
.meas tran v0_s18 FIND v(s_18) AT=4.150000e-08
.meas tran v0_s19 FIND v(s_19) AT=4.150000e-08
.meas tran v0_s20 FIND v(s_20) AT=4.150000e-08
.meas tran v0_s21 FIND v(s_21) AT=4.150000e-08
.meas tran v1_s0 FIND v(s_0) AT=8.150000e-08
.meas tran v1_s1 FIND v(s_1) AT=8.150000e-08
.meas tran v1_s2 FIND v(s_2) AT=8.150000e-08
.meas tran v1_s3 FIND v(s_3) AT=8.150000e-08
.meas tran v1_s4 FIND v(s_4) AT=8.150000e-08
.meas tran v1_s5 FIND v(s_5) AT=8.150000e-08
.meas tran v1_s6 FIND v(s_6) AT=8.150000e-08
.meas tran v1_s7 FIND v(s_7) AT=8.150000e-08
.meas tran v1_s8 FIND v(s_8) AT=8.150000e-08
.meas tran v1_s9 FIND v(s_9) AT=8.150000e-08
.meas tran v1_s10 FIND v(s_10) AT=8.150000e-08
.meas tran v1_s11 FIND v(s_11) AT=8.150000e-08
.meas tran v1_s12 FIND v(s_12) AT=8.150000e-08
.meas tran v1_s13 FIND v(s_13) AT=8.150000e-08
.meas tran v1_s14 FIND v(s_14) AT=8.150000e-08
.meas tran v1_s15 FIND v(s_15) AT=8.150000e-08
.meas tran v1_s16 FIND v(s_16) AT=8.150000e-08
.meas tran v1_s17 FIND v(s_17) AT=8.150000e-08
.meas tran v1_s18 FIND v(s_18) AT=8.150000e-08
.meas tran v1_s19 FIND v(s_19) AT=8.150000e-08
.meas tran v1_s20 FIND v(s_20) AT=8.150000e-08
.meas tran v1_s21 FIND v(s_21) AT=8.150000e-08
.meas tran v2_s0 FIND v(s_0) AT=1.215000e-07
.meas tran v2_s1 FIND v(s_1) AT=1.215000e-07
.meas tran v2_s2 FIND v(s_2) AT=1.215000e-07
.meas tran v2_s3 FIND v(s_3) AT=1.215000e-07
.meas tran v2_s4 FIND v(s_4) AT=1.215000e-07
.meas tran v2_s5 FIND v(s_5) AT=1.215000e-07
.meas tran v2_s6 FIND v(s_6) AT=1.215000e-07
.meas tran v2_s7 FIND v(s_7) AT=1.215000e-07
.meas tran v2_s8 FIND v(s_8) AT=1.215000e-07
.meas tran v2_s9 FIND v(s_9) AT=1.215000e-07
.meas tran v2_s10 FIND v(s_10) AT=1.215000e-07
.meas tran v2_s11 FIND v(s_11) AT=1.215000e-07
.meas tran v2_s12 FIND v(s_12) AT=1.215000e-07
.meas tran v2_s13 FIND v(s_13) AT=1.215000e-07
.meas tran v2_s14 FIND v(s_14) AT=1.215000e-07
.meas tran v2_s15 FIND v(s_15) AT=1.215000e-07
.meas tran v2_s16 FIND v(s_16) AT=1.215000e-07
.meas tran v2_s17 FIND v(s_17) AT=1.215000e-07
.meas tran v2_s18 FIND v(s_18) AT=1.215000e-07
.meas tran v2_s19 FIND v(s_19) AT=1.215000e-07
.meas tran v2_s20 FIND v(s_20) AT=1.215000e-07
.meas tran v2_s21 FIND v(s_21) AT=1.215000e-07
.meas tran v3_s0 FIND v(s_0) AT=1.615000e-07
.meas tran v3_s1 FIND v(s_1) AT=1.615000e-07
.meas tran v3_s2 FIND v(s_2) AT=1.615000e-07
.meas tran v3_s3 FIND v(s_3) AT=1.615000e-07
.meas tran v3_s4 FIND v(s_4) AT=1.615000e-07
.meas tran v3_s5 FIND v(s_5) AT=1.615000e-07
.meas tran v3_s6 FIND v(s_6) AT=1.615000e-07
.meas tran v3_s7 FIND v(s_7) AT=1.615000e-07
.meas tran v3_s8 FIND v(s_8) AT=1.615000e-07
.meas tran v3_s9 FIND v(s_9) AT=1.615000e-07
.meas tran v3_s10 FIND v(s_10) AT=1.615000e-07
.meas tran v3_s11 FIND v(s_11) AT=1.615000e-07
.meas tran v3_s12 FIND v(s_12) AT=1.615000e-07
.meas tran v3_s13 FIND v(s_13) AT=1.615000e-07
.meas tran v3_s14 FIND v(s_14) AT=1.615000e-07
.meas tran v3_s15 FIND v(s_15) AT=1.615000e-07
.meas tran v3_s16 FIND v(s_16) AT=1.615000e-07
.meas tran v3_s17 FIND v(s_17) AT=1.615000e-07
.meas tran v3_s18 FIND v(s_18) AT=1.615000e-07
.meas tran v3_s19 FIND v(s_19) AT=1.615000e-07
.meas tran v3_s20 FIND v(s_20) AT=1.615000e-07
.meas tran v3_s21 FIND v(s_21) AT=1.615000e-07
.meas tran v4_s0 FIND v(s_0) AT=2.015000e-07
.meas tran v4_s1 FIND v(s_1) AT=2.015000e-07
.meas tran v4_s2 FIND v(s_2) AT=2.015000e-07
.meas tran v4_s3 FIND v(s_3) AT=2.015000e-07
.meas tran v4_s4 FIND v(s_4) AT=2.015000e-07
.meas tran v4_s5 FIND v(s_5) AT=2.015000e-07
.meas tran v4_s6 FIND v(s_6) AT=2.015000e-07
.meas tran v4_s7 FIND v(s_7) AT=2.015000e-07
.meas tran v4_s8 FIND v(s_8) AT=2.015000e-07
.meas tran v4_s9 FIND v(s_9) AT=2.015000e-07
.meas tran v4_s10 FIND v(s_10) AT=2.015000e-07
.meas tran v4_s11 FIND v(s_11) AT=2.015000e-07
.meas tran v4_s12 FIND v(s_12) AT=2.015000e-07
.meas tran v4_s13 FIND v(s_13) AT=2.015000e-07
.meas tran v4_s14 FIND v(s_14) AT=2.015000e-07
.meas tran v4_s15 FIND v(s_15) AT=2.015000e-07
.meas tran v4_s16 FIND v(s_16) AT=2.015000e-07
.meas tran v4_s17 FIND v(s_17) AT=2.015000e-07
.meas tran v4_s18 FIND v(s_18) AT=2.015000e-07
.meas tran v4_s19 FIND v(s_19) AT=2.015000e-07
.meas tran v4_s20 FIND v(s_20) AT=2.015000e-07
.meas tran v4_s21 FIND v(s_21) AT=2.015000e-07
.meas tran v5_s0 FIND v(s_0) AT=2.415000e-07
.meas tran v5_s1 FIND v(s_1) AT=2.415000e-07
.meas tran v5_s2 FIND v(s_2) AT=2.415000e-07
.meas tran v5_s3 FIND v(s_3) AT=2.415000e-07
.meas tran v5_s4 FIND v(s_4) AT=2.415000e-07
.meas tran v5_s5 FIND v(s_5) AT=2.415000e-07
.meas tran v5_s6 FIND v(s_6) AT=2.415000e-07
.meas tran v5_s7 FIND v(s_7) AT=2.415000e-07
.meas tran v5_s8 FIND v(s_8) AT=2.415000e-07
.meas tran v5_s9 FIND v(s_9) AT=2.415000e-07
.meas tran v5_s10 FIND v(s_10) AT=2.415000e-07
.meas tran v5_s11 FIND v(s_11) AT=2.415000e-07
.meas tran v5_s12 FIND v(s_12) AT=2.415000e-07
.meas tran v5_s13 FIND v(s_13) AT=2.415000e-07
.meas tran v5_s14 FIND v(s_14) AT=2.415000e-07
.meas tran v5_s15 FIND v(s_15) AT=2.415000e-07
.meas tran v5_s16 FIND v(s_16) AT=2.415000e-07
.meas tran v5_s17 FIND v(s_17) AT=2.415000e-07
.meas tran v5_s18 FIND v(s_18) AT=2.415000e-07
.meas tran v5_s19 FIND v(s_19) AT=2.415000e-07
.meas tran v5_s20 FIND v(s_20) AT=2.415000e-07
.meas tran v5_s21 FIND v(s_21) AT=2.415000e-07
.meas tran v6_s0 FIND v(s_0) AT=2.815000e-07
.meas tran v6_s1 FIND v(s_1) AT=2.815000e-07
.meas tran v6_s2 FIND v(s_2) AT=2.815000e-07
.meas tran v6_s3 FIND v(s_3) AT=2.815000e-07
.meas tran v6_s4 FIND v(s_4) AT=2.815000e-07
.meas tran v6_s5 FIND v(s_5) AT=2.815000e-07
.meas tran v6_s6 FIND v(s_6) AT=2.815000e-07
.meas tran v6_s7 FIND v(s_7) AT=2.815000e-07
.meas tran v6_s8 FIND v(s_8) AT=2.815000e-07
.meas tran v6_s9 FIND v(s_9) AT=2.815000e-07
.meas tran v6_s10 FIND v(s_10) AT=2.815000e-07
.meas tran v6_s11 FIND v(s_11) AT=2.815000e-07
.meas tran v6_s12 FIND v(s_12) AT=2.815000e-07
.meas tran v6_s13 FIND v(s_13) AT=2.815000e-07
.meas tran v6_s14 FIND v(s_14) AT=2.815000e-07
.meas tran v6_s15 FIND v(s_15) AT=2.815000e-07
.meas tran v6_s16 FIND v(s_16) AT=2.815000e-07
.meas tran v6_s17 FIND v(s_17) AT=2.815000e-07
.meas tran v6_s18 FIND v(s_18) AT=2.815000e-07
.meas tran v6_s19 FIND v(s_19) AT=2.815000e-07
.meas tran v6_s20 FIND v(s_20) AT=2.815000e-07
.meas tran v6_s21 FIND v(s_21) AT=2.815000e-07
.meas tran v7_s0 FIND v(s_0) AT=3.215000e-07
.meas tran v7_s1 FIND v(s_1) AT=3.215000e-07
.meas tran v7_s2 FIND v(s_2) AT=3.215000e-07
.meas tran v7_s3 FIND v(s_3) AT=3.215000e-07
.meas tran v7_s4 FIND v(s_4) AT=3.215000e-07
.meas tran v7_s5 FIND v(s_5) AT=3.215000e-07
.meas tran v7_s6 FIND v(s_6) AT=3.215000e-07
.meas tran v7_s7 FIND v(s_7) AT=3.215000e-07
.meas tran v7_s8 FIND v(s_8) AT=3.215000e-07
.meas tran v7_s9 FIND v(s_9) AT=3.215000e-07
.meas tran v7_s10 FIND v(s_10) AT=3.215000e-07
.meas tran v7_s11 FIND v(s_11) AT=3.215000e-07
.meas tran v7_s12 FIND v(s_12) AT=3.215000e-07
.meas tran v7_s13 FIND v(s_13) AT=3.215000e-07
.meas tran v7_s14 FIND v(s_14) AT=3.215000e-07
.meas tran v7_s15 FIND v(s_15) AT=3.215000e-07
.meas tran v7_s16 FIND v(s_16) AT=3.215000e-07
.meas tran v7_s17 FIND v(s_17) AT=3.215000e-07
.meas tran v7_s18 FIND v(s_18) AT=3.215000e-07
.meas tran v7_s19 FIND v(s_19) AT=3.215000e-07
.meas tran v7_s20 FIND v(s_20) AT=3.215000e-07
.meas tran v7_s21 FIND v(s_21) AT=3.215000e-07
.meas tran v8_s0 FIND v(s_0) AT=3.615000e-07
.meas tran v8_s1 FIND v(s_1) AT=3.615000e-07
.meas tran v8_s2 FIND v(s_2) AT=3.615000e-07
.meas tran v8_s3 FIND v(s_3) AT=3.615000e-07
.meas tran v8_s4 FIND v(s_4) AT=3.615000e-07
.meas tran v8_s5 FIND v(s_5) AT=3.615000e-07
.meas tran v8_s6 FIND v(s_6) AT=3.615000e-07
.meas tran v8_s7 FIND v(s_7) AT=3.615000e-07
.meas tran v8_s8 FIND v(s_8) AT=3.615000e-07
.meas tran v8_s9 FIND v(s_9) AT=3.615000e-07
.meas tran v8_s10 FIND v(s_10) AT=3.615000e-07
.meas tran v8_s11 FIND v(s_11) AT=3.615000e-07
.meas tran v8_s12 FIND v(s_12) AT=3.615000e-07
.meas tran v8_s13 FIND v(s_13) AT=3.615000e-07
.meas tran v8_s14 FIND v(s_14) AT=3.615000e-07
.meas tran v8_s15 FIND v(s_15) AT=3.615000e-07
.meas tran v8_s16 FIND v(s_16) AT=3.615000e-07
.meas tran v8_s17 FIND v(s_17) AT=3.615000e-07
.meas tran v8_s18 FIND v(s_18) AT=3.615000e-07
.meas tran v8_s19 FIND v(s_19) AT=3.615000e-07
.meas tran v8_s20 FIND v(s_20) AT=3.615000e-07
.meas tran v8_s21 FIND v(s_21) AT=3.615000e-07
.meas tran v9_s0 FIND v(s_0) AT=4.015000e-07
.meas tran v9_s1 FIND v(s_1) AT=4.015000e-07
.meas tran v9_s2 FIND v(s_2) AT=4.015000e-07
.meas tran v9_s3 FIND v(s_3) AT=4.015000e-07
.meas tran v9_s4 FIND v(s_4) AT=4.015000e-07
.meas tran v9_s5 FIND v(s_5) AT=4.015000e-07
.meas tran v9_s6 FIND v(s_6) AT=4.015000e-07
.meas tran v9_s7 FIND v(s_7) AT=4.015000e-07
.meas tran v9_s8 FIND v(s_8) AT=4.015000e-07
.meas tran v9_s9 FIND v(s_9) AT=4.015000e-07
.meas tran v9_s10 FIND v(s_10) AT=4.015000e-07
.meas tran v9_s11 FIND v(s_11) AT=4.015000e-07
.meas tran v9_s12 FIND v(s_12) AT=4.015000e-07
.meas tran v9_s13 FIND v(s_13) AT=4.015000e-07
.meas tran v9_s14 FIND v(s_14) AT=4.015000e-07
.meas tran v9_s15 FIND v(s_15) AT=4.015000e-07
.meas tran v9_s16 FIND v(s_16) AT=4.015000e-07
.meas tran v9_s17 FIND v(s_17) AT=4.015000e-07
.meas tran v9_s18 FIND v(s_18) AT=4.015000e-07
.meas tran v9_s19 FIND v(s_19) AT=4.015000e-07
.meas tran v9_s20 FIND v(s_20) AT=4.015000e-07
.meas tran v9_s21 FIND v(s_21) AT=4.015000e-07
.meas tran v10_s0 FIND v(s_0) AT=4.415000e-07
.meas tran v10_s1 FIND v(s_1) AT=4.415000e-07
.meas tran v10_s2 FIND v(s_2) AT=4.415000e-07
.meas tran v10_s3 FIND v(s_3) AT=4.415000e-07
.meas tran v10_s4 FIND v(s_4) AT=4.415000e-07
.meas tran v10_s5 FIND v(s_5) AT=4.415000e-07
.meas tran v10_s6 FIND v(s_6) AT=4.415000e-07
.meas tran v10_s7 FIND v(s_7) AT=4.415000e-07
.meas tran v10_s8 FIND v(s_8) AT=4.415000e-07
.meas tran v10_s9 FIND v(s_9) AT=4.415000e-07
.meas tran v10_s10 FIND v(s_10) AT=4.415000e-07
.meas tran v10_s11 FIND v(s_11) AT=4.415000e-07
.meas tran v10_s12 FIND v(s_12) AT=4.415000e-07
.meas tran v10_s13 FIND v(s_13) AT=4.415000e-07
.meas tran v10_s14 FIND v(s_14) AT=4.415000e-07
.meas tran v10_s15 FIND v(s_15) AT=4.415000e-07
.meas tran v10_s16 FIND v(s_16) AT=4.415000e-07
.meas tran v10_s17 FIND v(s_17) AT=4.415000e-07
.meas tran v10_s18 FIND v(s_18) AT=4.415000e-07
.meas tran v10_s19 FIND v(s_19) AT=4.415000e-07
.meas tran v10_s20 FIND v(s_20) AT=4.415000e-07
.meas tran v10_s21 FIND v(s_21) AT=4.415000e-07
.meas tran v11_s0 FIND v(s_0) AT=4.815000e-07
.meas tran v11_s1 FIND v(s_1) AT=4.815000e-07
.meas tran v11_s2 FIND v(s_2) AT=4.815000e-07
.meas tran v11_s3 FIND v(s_3) AT=4.815000e-07
.meas tran v11_s4 FIND v(s_4) AT=4.815000e-07
.meas tran v11_s5 FIND v(s_5) AT=4.815000e-07
.meas tran v11_s6 FIND v(s_6) AT=4.815000e-07
.meas tran v11_s7 FIND v(s_7) AT=4.815000e-07
.meas tran v11_s8 FIND v(s_8) AT=4.815000e-07
.meas tran v11_s9 FIND v(s_9) AT=4.815000e-07
.meas tran v11_s10 FIND v(s_10) AT=4.815000e-07
.meas tran v11_s11 FIND v(s_11) AT=4.815000e-07
.meas tran v11_s12 FIND v(s_12) AT=4.815000e-07
.meas tran v11_s13 FIND v(s_13) AT=4.815000e-07
.meas tran v11_s14 FIND v(s_14) AT=4.815000e-07
.meas tran v11_s15 FIND v(s_15) AT=4.815000e-07
.meas tran v11_s16 FIND v(s_16) AT=4.815000e-07
.meas tran v11_s17 FIND v(s_17) AT=4.815000e-07
.meas tran v11_s18 FIND v(s_18) AT=4.815000e-07
.meas tran v11_s19 FIND v(s_19) AT=4.815000e-07
.meas tran v11_s20 FIND v(s_20) AT=4.815000e-07
.meas tran v11_s21 FIND v(s_21) AT=4.815000e-07
.meas tran v12_s0 FIND v(s_0) AT=5.215000e-07
.meas tran v12_s1 FIND v(s_1) AT=5.215000e-07
.meas tran v12_s2 FIND v(s_2) AT=5.215000e-07
.meas tran v12_s3 FIND v(s_3) AT=5.215000e-07
.meas tran v12_s4 FIND v(s_4) AT=5.215000e-07
.meas tran v12_s5 FIND v(s_5) AT=5.215000e-07
.meas tran v12_s6 FIND v(s_6) AT=5.215000e-07
.meas tran v12_s7 FIND v(s_7) AT=5.215000e-07
.meas tran v12_s8 FIND v(s_8) AT=5.215000e-07
.meas tran v12_s9 FIND v(s_9) AT=5.215000e-07
.meas tran v12_s10 FIND v(s_10) AT=5.215000e-07
.meas tran v12_s11 FIND v(s_11) AT=5.215000e-07
.meas tran v12_s12 FIND v(s_12) AT=5.215000e-07
.meas tran v12_s13 FIND v(s_13) AT=5.215000e-07
.meas tran v12_s14 FIND v(s_14) AT=5.215000e-07
.meas tran v12_s15 FIND v(s_15) AT=5.215000e-07
.meas tran v12_s16 FIND v(s_16) AT=5.215000e-07
.meas tran v12_s17 FIND v(s_17) AT=5.215000e-07
.meas tran v12_s18 FIND v(s_18) AT=5.215000e-07
.meas tran v12_s19 FIND v(s_19) AT=5.215000e-07
.meas tran v12_s20 FIND v(s_20) AT=5.215000e-07
.meas tran v12_s21 FIND v(s_21) AT=5.215000e-07
.meas tran v13_s0 FIND v(s_0) AT=5.615000e-07
.meas tran v13_s1 FIND v(s_1) AT=5.615000e-07
.meas tran v13_s2 FIND v(s_2) AT=5.615000e-07
.meas tran v13_s3 FIND v(s_3) AT=5.615000e-07
.meas tran v13_s4 FIND v(s_4) AT=5.615000e-07
.meas tran v13_s5 FIND v(s_5) AT=5.615000e-07
.meas tran v13_s6 FIND v(s_6) AT=5.615000e-07
.meas tran v13_s7 FIND v(s_7) AT=5.615000e-07
.meas tran v13_s8 FIND v(s_8) AT=5.615000e-07
.meas tran v13_s9 FIND v(s_9) AT=5.615000e-07
.meas tran v13_s10 FIND v(s_10) AT=5.615000e-07
.meas tran v13_s11 FIND v(s_11) AT=5.615000e-07
.meas tran v13_s12 FIND v(s_12) AT=5.615000e-07
.meas tran v13_s13 FIND v(s_13) AT=5.615000e-07
.meas tran v13_s14 FIND v(s_14) AT=5.615000e-07
.meas tran v13_s15 FIND v(s_15) AT=5.615000e-07
.meas tran v13_s16 FIND v(s_16) AT=5.615000e-07
.meas tran v13_s17 FIND v(s_17) AT=5.615000e-07
.meas tran v13_s18 FIND v(s_18) AT=5.615000e-07
.meas tran v13_s19 FIND v(s_19) AT=5.615000e-07
.meas tran v13_s20 FIND v(s_20) AT=5.615000e-07
.meas tran v13_s21 FIND v(s_21) AT=5.615000e-07
.meas tran v14_s0 FIND v(s_0) AT=6.015000e-07
.meas tran v14_s1 FIND v(s_1) AT=6.015000e-07
.meas tran v14_s2 FIND v(s_2) AT=6.015000e-07
.meas tran v14_s3 FIND v(s_3) AT=6.015000e-07
.meas tran v14_s4 FIND v(s_4) AT=6.015000e-07
.meas tran v14_s5 FIND v(s_5) AT=6.015000e-07
.meas tran v14_s6 FIND v(s_6) AT=6.015000e-07
.meas tran v14_s7 FIND v(s_7) AT=6.015000e-07
.meas tran v14_s8 FIND v(s_8) AT=6.015000e-07
.meas tran v14_s9 FIND v(s_9) AT=6.015000e-07
.meas tran v14_s10 FIND v(s_10) AT=6.015000e-07
.meas tran v14_s11 FIND v(s_11) AT=6.015000e-07
.meas tran v14_s12 FIND v(s_12) AT=6.015000e-07
.meas tran v14_s13 FIND v(s_13) AT=6.015000e-07
.meas tran v14_s14 FIND v(s_14) AT=6.015000e-07
.meas tran v14_s15 FIND v(s_15) AT=6.015000e-07
.meas tran v14_s16 FIND v(s_16) AT=6.015000e-07
.meas tran v14_s17 FIND v(s_17) AT=6.015000e-07
.meas tran v14_s18 FIND v(s_18) AT=6.015000e-07
.meas tran v14_s19 FIND v(s_19) AT=6.015000e-07
.meas tran v14_s20 FIND v(s_20) AT=6.015000e-07
.meas tran v14_s21 FIND v(s_21) AT=6.015000e-07
.meas tran v15_s0 FIND v(s_0) AT=6.415000e-07
.meas tran v15_s1 FIND v(s_1) AT=6.415000e-07
.meas tran v15_s2 FIND v(s_2) AT=6.415000e-07
.meas tran v15_s3 FIND v(s_3) AT=6.415000e-07
.meas tran v15_s4 FIND v(s_4) AT=6.415000e-07
.meas tran v15_s5 FIND v(s_5) AT=6.415000e-07
.meas tran v15_s6 FIND v(s_6) AT=6.415000e-07
.meas tran v15_s7 FIND v(s_7) AT=6.415000e-07
.meas tran v15_s8 FIND v(s_8) AT=6.415000e-07
.meas tran v15_s9 FIND v(s_9) AT=6.415000e-07
.meas tran v15_s10 FIND v(s_10) AT=6.415000e-07
.meas tran v15_s11 FIND v(s_11) AT=6.415000e-07
.meas tran v15_s12 FIND v(s_12) AT=6.415000e-07
.meas tran v15_s13 FIND v(s_13) AT=6.415000e-07
.meas tran v15_s14 FIND v(s_14) AT=6.415000e-07
.meas tran v15_s15 FIND v(s_15) AT=6.415000e-07
.meas tran v15_s16 FIND v(s_16) AT=6.415000e-07
.meas tran v15_s17 FIND v(s_17) AT=6.415000e-07
.meas tran v15_s18 FIND v(s_18) AT=6.415000e-07
.meas tran v15_s19 FIND v(s_19) AT=6.415000e-07
.meas tran v15_s20 FIND v(s_20) AT=6.415000e-07
.meas tran v15_s21 FIND v(s_21) AT=6.415000e-07
.meas tran v16_s0 FIND v(s_0) AT=6.815000e-07
.meas tran v16_s1 FIND v(s_1) AT=6.815000e-07
.meas tran v16_s2 FIND v(s_2) AT=6.815000e-07
.meas tran v16_s3 FIND v(s_3) AT=6.815000e-07
.meas tran v16_s4 FIND v(s_4) AT=6.815000e-07
.meas tran v16_s5 FIND v(s_5) AT=6.815000e-07
.meas tran v16_s6 FIND v(s_6) AT=6.815000e-07
.meas tran v16_s7 FIND v(s_7) AT=6.815000e-07
.meas tran v16_s8 FIND v(s_8) AT=6.815000e-07
.meas tran v16_s9 FIND v(s_9) AT=6.815000e-07
.meas tran v16_s10 FIND v(s_10) AT=6.815000e-07
.meas tran v16_s11 FIND v(s_11) AT=6.815000e-07
.meas tran v16_s12 FIND v(s_12) AT=6.815000e-07
.meas tran v16_s13 FIND v(s_13) AT=6.815000e-07
.meas tran v16_s14 FIND v(s_14) AT=6.815000e-07
.meas tran v16_s15 FIND v(s_15) AT=6.815000e-07
.meas tran v16_s16 FIND v(s_16) AT=6.815000e-07
.meas tran v16_s17 FIND v(s_17) AT=6.815000e-07
.meas tran v16_s18 FIND v(s_18) AT=6.815000e-07
.meas tran v16_s19 FIND v(s_19) AT=6.815000e-07
.meas tran v16_s20 FIND v(s_20) AT=6.815000e-07
.meas tran v16_s21 FIND v(s_21) AT=6.815000e-07
.meas tran v17_s0 FIND v(s_0) AT=7.215000e-07
.meas tran v17_s1 FIND v(s_1) AT=7.215000e-07
.meas tran v17_s2 FIND v(s_2) AT=7.215000e-07
.meas tran v17_s3 FIND v(s_3) AT=7.215000e-07
.meas tran v17_s4 FIND v(s_4) AT=7.215000e-07
.meas tran v17_s5 FIND v(s_5) AT=7.215000e-07
.meas tran v17_s6 FIND v(s_6) AT=7.215000e-07
.meas tran v17_s7 FIND v(s_7) AT=7.215000e-07
.meas tran v17_s8 FIND v(s_8) AT=7.215000e-07
.meas tran v17_s9 FIND v(s_9) AT=7.215000e-07
.meas tran v17_s10 FIND v(s_10) AT=7.215000e-07
.meas tran v17_s11 FIND v(s_11) AT=7.215000e-07
.meas tran v17_s12 FIND v(s_12) AT=7.215000e-07
.meas tran v17_s13 FIND v(s_13) AT=7.215000e-07
.meas tran v17_s14 FIND v(s_14) AT=7.215000e-07
.meas tran v17_s15 FIND v(s_15) AT=7.215000e-07
.meas tran v17_s16 FIND v(s_16) AT=7.215000e-07
.meas tran v17_s17 FIND v(s_17) AT=7.215000e-07
.meas tran v17_s18 FIND v(s_18) AT=7.215000e-07
.meas tran v17_s19 FIND v(s_19) AT=7.215000e-07
.meas tran v17_s20 FIND v(s_20) AT=7.215000e-07
.meas tran v17_s21 FIND v(s_21) AT=7.215000e-07
.meas tran v18_s0 FIND v(s_0) AT=7.615000e-07
.meas tran v18_s1 FIND v(s_1) AT=7.615000e-07
.meas tran v18_s2 FIND v(s_2) AT=7.615000e-07
.meas tran v18_s3 FIND v(s_3) AT=7.615000e-07
.meas tran v18_s4 FIND v(s_4) AT=7.615000e-07
.meas tran v18_s5 FIND v(s_5) AT=7.615000e-07
.meas tran v18_s6 FIND v(s_6) AT=7.615000e-07
.meas tran v18_s7 FIND v(s_7) AT=7.615000e-07
.meas tran v18_s8 FIND v(s_8) AT=7.615000e-07
.meas tran v18_s9 FIND v(s_9) AT=7.615000e-07
.meas tran v18_s10 FIND v(s_10) AT=7.615000e-07
.meas tran v18_s11 FIND v(s_11) AT=7.615000e-07
.meas tran v18_s12 FIND v(s_12) AT=7.615000e-07
.meas tran v18_s13 FIND v(s_13) AT=7.615000e-07
.meas tran v18_s14 FIND v(s_14) AT=7.615000e-07
.meas tran v18_s15 FIND v(s_15) AT=7.615000e-07
.meas tran v18_s16 FIND v(s_16) AT=7.615000e-07
.meas tran v18_s17 FIND v(s_17) AT=7.615000e-07
.meas tran v18_s18 FIND v(s_18) AT=7.615000e-07
.meas tran v18_s19 FIND v(s_19) AT=7.615000e-07
.meas tran v18_s20 FIND v(s_20) AT=7.615000e-07
.meas tran v18_s21 FIND v(s_21) AT=7.615000e-07
.tran 20p 7.620000e-07
.end
