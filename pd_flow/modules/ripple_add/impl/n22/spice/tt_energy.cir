* ripple_add N=22 energy, corner tt
.include /Users/samuelzhang/ttsetup/pdk/ciel/gf180mcu/versions/54435919abffb937387ec956209f9cf5fd2dfbee/gf180mcuD/libs.tech/ngspice/design.ngspice
.lib /Users/samuelzhang/ttsetup/pdk/ciel/gf180mcu/versions/54435919abffb937387ec956209f9cf5fd2dfbee/gf180mcuD/libs.tech/ngspice/sm141064.ngspice typical
.include ../pex/ripple_add_n22_pex.spice
.temp 25
.options method=gear reltol=1e-4 abstol=1e-13
VDD vpwr 0 3.3
X1 0 vpwr a_0 a_10 a_11 a_12 a_13 a_14 a_15 a_16 a_17 a_18 a_19 a_1 a_20 a_21 a_2 a_3 a_4 a_5 a_6 a_7 a_8 a_9 b_0 b_10 b_11 b_12 b_13 b_14 b_15 b_16 b_17 b_18 b_19 b_1 b_20 b_21 b_2 b_3 b_4 b_5 b_6 b_7 b_8 b_9 cin s_0 s_10 s_11 s_12 s_13 s_14 s_15 s_16 s_17 s_18 s_19 s_1 s_20 s_21 s_2 s_3 s_4 s_5 s_6 s_7 s_8 s_9 ripple_add
C_s_0 s_0 0 2e-14
C_s_1 s_1 0 2e-14
C_s_2 s_2 0 2e-14
C_s_3 s_3 0 2e-14
C_s_4 s_4 0 2e-14
C_s_5 s_5 0 2e-14
C_s_6 s_6 0 2e-14
C_s_7 s_7 0 2e-14
C_s_8 s_8 0 2e-14
C_s_9 s_9 0 2e-14
C_s_10 s_10 0 2e-14
C_s_11 s_11 0 2e-14
C_s_12 s_12 0 2e-14
C_s_13 s_13 0 2e-14
C_s_14 s_14 0 2e-14
C_s_15 s_15 0 2e-14
C_s_16 s_16 0 2e-14
C_s_17 s_17 0 2e-14
C_s_18 s_18 0 2e-14
C_s_19 s_19 0 2e-14
C_s_20 s_20 0 2e-14
C_s_21 s_21 0 2e-14
V_a_0 a_0 0 PWL(0.000000e+00 3.3000 1.220000e-07 3.3000 1.223750e-07 0.0000 1.620000e-07 0.0000 1.623750e-07 3.3000 3.220000e-07 3.3000 3.223750e-07 0.0000 4.820000e-07 0.0000 4.823750e-07 3.3000 5.220000e-07 3.3000 5.223750e-07 0.0000 5.620000e-07 0.0000 5.623750e-07 3.3000 7.220000e-07 3.3000 7.223750e-07 0.0000 8.020000e-07 0.0000 8.023750e-07 3.3000 8.820000e-07 3.3000 8.823750e-07 0.0000 1.002000e-06 0.0000 1.002375e-06 3.3000 1.042000e-06 3.3000 1.042375e-06 0.0000 1.122000e-06 0.0000 1.122375e-06 3.3000 1.162000e-06 3.3000 1.162375e-06 0.0000 1.202000e-06 0.0000 1.202375e-06 3.3000 1.242000e-06 3.3000 1.242375e-06 0.0000 1.282000e-06 0.0000 1.282375e-06 3.3000 1.522000e-06 3.3000 1.522375e-06 0.0000 1.562000e-06 0.0000 1.562375e-06 3.3000 1.602000e-06 3.3000 1.602375e-06 0.0000 1.642000e-06 0.0000 1.642375e-06 3.3000)
V_a_1 a_1 0 PWL(0.000000e+00 0.0000 8.200000e-08 0.0000 8.237500e-08 3.3000 1.620000e-07 3.3000 1.623750e-07 0.0000 3.220000e-07 0.0000 3.223750e-07 3.3000 3.620000e-07 3.3000 3.623750e-07 0.0000 4.420000e-07 0.0000 4.423750e-07 3.3000 4.820000e-07 3.3000 4.823750e-07 0.0000 6.020000e-07 0.0000 6.023750e-07 3.3000 6.420000e-07 3.3000 6.423750e-07 0.0000 7.220000e-07 0.0000 7.223750e-07 3.3000 8.020000e-07 3.3000 8.023750e-07 0.0000 9.220000e-07 0.0000 9.223750e-07 3.3000 9.620000e-07 3.3000 9.623750e-07 0.0000 1.082000e-06 0.0000 1.082375e-06 3.3000 1.122000e-06 3.3000 1.122375e-06 0.0000 1.162000e-06 0.0000 1.162375e-06 3.3000 1.242000e-06 3.3000 1.242375e-06 0.0000 1.282000e-06 0.0000 1.282375e-06 3.3000 1.402000e-06 3.3000 1.402375e-06 0.0000 1.482000e-06 0.0000 1.482375e-06 3.3000 1.522000e-06 3.3000 1.522375e-06 0.0000 1.562000e-06 0.0000 1.562375e-06 3.3000 1.602000e-06 3.3000 1.602375e-06 0.0000 1.642000e-06 0.0000 1.642375e-06 3.3000)
V_a_2 a_2 0 PWL(0.000000e+00 3.3000 4.200000e-08 3.3000 4.237500e-08 0.0000 2.020000e-07 0.0000 2.023750e-07 3.3000 2.420000e-07 3.3000 2.423750e-07 0.0000 2.820000e-07 0.0000 2.823750e-07 3.3000 3.220000e-07 3.3000 3.223750e-07 0.0000 3.620000e-07 0.0000 3.623750e-07 3.3000 4.420000e-07 3.3000 4.423750e-07 0.0000 5.620000e-07 0.0000 5.623750e-07 3.3000 6.420000e-07 3.3000 6.423750e-07 0.0000 7.620000e-07 0.0000 7.623750e-07 3.3000 9.220000e-07 3.3000 9.223750e-07 0.0000 9.620000e-07 0.0000 9.623750e-07 3.3000 1.042000e-06 3.3000 1.042375e-06 0.0000 1.122000e-06 0.0000 1.122375e-06 3.3000 1.162000e-06 3.3000 1.162375e-06 0.0000 1.242000e-06 0.0000 1.242375e-06 3.3000 1.282000e-06 3.3000 1.282375e-06 0.0000 1.322000e-06 0.0000 1.322375e-06 3.3000 1.362000e-06 3.3000 1.362375e-06 0.0000 1.402000e-06 0.0000 1.402375e-06 3.3000 1.482000e-06 3.3000 1.482375e-06 0.0000 1.522000e-06 0.0000 1.522375e-06 3.3000 1.562000e-06 3.3000 1.562375e-06 0.0000 1.602000e-06 0.0000 1.602375e-06 3.3000)
V_a_3 a_3 0 PWL(0.000000e+00 3.3000 1.620000e-07 3.3000 1.623750e-07 0.0000 2.020000e-07 0.0000 2.023750e-07 3.3000 2.820000e-07 3.3000 2.823750e-07 0.0000 4.020000e-07 0.0000 4.023750e-07 3.3000 4.420000e-07 3.3000 4.423750e-07 0.0000 5.220000e-07 0.0000 5.223750e-07 3.3000 5.620000e-07 3.3000 5.623750e-07 0.0000 6.020000e-07 0.0000 6.023750e-07 3.3000 7.620000e-07 3.3000 7.623750e-07 0.0000 8.420000e-07 0.0000 8.423750e-07 3.3000 1.362000e-06 3.3000 1.362375e-06 0.0000 1.402000e-06 0.0000 1.402375e-06 3.3000 1.562000e-06 3.3000 1.562375e-06 0.0000 1.642000e-06 0.0000 1.642375e-06 3.3000)
V_a_4 a_4 0 PWL(0.000000e+00 0.0000 1.220000e-07 0.0000 1.223750e-07 3.3000 1.620000e-07 3.3000 1.623750e-07 0.0000 2.020000e-07 0.0000 2.023750e-07 3.3000 2.820000e-07 3.3000 2.823750e-07 0.0000 3.220000e-07 0.0000 3.223750e-07 3.3000 3.620000e-07 3.3000 3.623750e-07 0.0000 4.420000e-07 0.0000 4.423750e-07 3.3000 4.820000e-07 3.3000 4.823750e-07 0.0000 5.220000e-07 0.0000 5.223750e-07 3.3000 6.020000e-07 3.3000 6.023750e-07 0.0000 6.420000e-07 0.0000 6.423750e-07 3.3000 7.220000e-07 3.3000 7.223750e-07 0.0000 7.620000e-07 0.0000 7.623750e-07 3.3000 8.420000e-07 3.3000 8.423750e-07 0.0000 8.820000e-07 0.0000 8.823750e-07 3.3000 9.620000e-07 3.3000 9.623750e-07 0.0000 1.002000e-06 0.0000 1.002375e-06 3.3000 1.082000e-06 3.3000 1.082375e-06 0.0000 1.122000e-06 0.0000 1.122375e-06 3.3000 1.322000e-06 3.3000 1.322375e-06 0.0000 1.402000e-06 0.0000 1.402375e-06 3.3000 1.522000e-06 3.3000 1.522375e-06 0.0000 1.602000e-06 0.0000 1.602375e-06 3.3000)
V_a_5 a_5 0 PWL(0.000000e+00 3.3000 4.200000e-08 3.3000 4.237500e-08 0.0000 1.220000e-07 0.0000 1.223750e-07 3.3000 1.620000e-07 3.3000 1.623750e-07 0.0000 3.620000e-07 0.0000 3.623750e-07 3.3000 4.020000e-07 3.3000 4.023750e-07 0.0000 5.220000e-07 0.0000 5.223750e-07 3.3000 6.820000e-07 3.3000 6.823750e-07 0.0000 7.220000e-07 0.0000 7.223750e-07 3.3000 8.420000e-07 3.3000 8.423750e-07 0.0000 8.820000e-07 0.0000 8.823750e-07 3.3000 9.220000e-07 3.3000 9.223750e-07 0.0000 9.620000e-07 0.0000 9.623750e-07 3.3000 1.002000e-06 3.3000 1.002375e-06 0.0000 1.082000e-06 0.0000 1.082375e-06 3.3000 1.122000e-06 3.3000 1.122375e-06 0.0000 1.162000e-06 0.0000 1.162375e-06 3.3000 1.202000e-06 3.3000 1.202375e-06 0.0000 1.242000e-06 0.0000 1.242375e-06 3.3000 1.442000e-06 3.3000 1.442375e-06 0.0000 1.642000e-06 0.0000 1.642375e-06 3.3000)
V_a_6 a_6 0 PWL(0.000000e+00 0.0000 4.200000e-08 0.0000 4.237500e-08 3.3000 1.220000e-07 3.3000 1.223750e-07 0.0000 1.620000e-07 0.0000 1.623750e-07 3.3000 2.020000e-07 3.3000 2.023750e-07 0.0000 2.420000e-07 0.0000 2.423750e-07 3.3000 2.820000e-07 3.3000 2.823750e-07 0.0000 3.220000e-07 0.0000 3.223750e-07 3.3000 4.020000e-07 3.3000 4.023750e-07 0.0000 4.420000e-07 0.0000 4.423750e-07 3.3000 5.620000e-07 3.3000 5.623750e-07 0.0000 6.020000e-07 0.0000 6.023750e-07 3.3000 8.820000e-07 3.3000 8.823750e-07 0.0000 9.220000e-07 0.0000 9.223750e-07 3.3000 9.620000e-07 3.3000 9.623750e-07 0.0000 1.042000e-06 0.0000 1.042375e-06 3.3000 1.082000e-06 3.3000 1.082375e-06 0.0000 1.202000e-06 0.0000 1.202375e-06 3.3000 1.282000e-06 3.3000 1.282375e-06 0.0000 1.362000e-06 0.0000 1.362375e-06 3.3000 1.402000e-06 3.3000 1.402375e-06 0.0000 1.602000e-06 0.0000 1.602375e-06 3.3000)
V_a_7 a_7 0 PWL(0.000000e+00 3.3000 1.220000e-07 3.3000 1.223750e-07 0.0000 2.020000e-07 0.0000 2.023750e-07 3.3000 2.820000e-07 3.3000 2.823750e-07 0.0000 4.020000e-07 0.0000 4.023750e-07 3.3000 4.820000e-07 3.3000 4.823750e-07 0.0000 6.020000e-07 0.0000 6.023750e-07 3.3000 6.420000e-07 3.3000 6.423750e-07 0.0000 6.820000e-07 0.0000 6.823750e-07 3.3000 7.220000e-07 3.3000 7.223750e-07 0.0000 8.020000e-07 0.0000 8.023750e-07 3.3000 8.420000e-07 3.3000 8.423750e-07 0.0000 8.820000e-07 0.0000 8.823750e-07 3.3000 1.002000e-06 3.3000 1.002375e-06 0.0000 1.042000e-06 0.0000 1.042375e-06 3.3000 1.082000e-06 3.3000 1.082375e-06 0.0000 1.162000e-06 0.0000 1.162375e-06 3.3000 1.202000e-06 3.3000 1.202375e-06 0.0000 1.242000e-06 0.0000 1.242375e-06 3.3000 1.282000e-06 3.3000 1.282375e-06 0.0000 1.402000e-06 0.0000 1.402375e-06 3.3000 1.442000e-06 3.3000 1.442375e-06 0.0000 1.562000e-06 0.0000 1.562375e-06 3.3000)
V_a_8 a_8 0 PWL(0.000000e+00 3.3000 4.200000e-08 3.3000 4.237500e-08 0.0000 2.020000e-07 0.0000 2.023750e-07 3.3000 2.420000e-07 3.3000 2.423750e-07 0.0000 2.820000e-07 0.0000 2.823750e-07 3.3000 3.620000e-07 3.3000 3.623750e-07 0.0000 4.020000e-07 0.0000 4.023750e-07 3.3000 5.220000e-07 3.3000 5.223750e-07 0.0000 5.620000e-07 0.0000 5.623750e-07 3.3000 7.620000e-07 3.3000 7.623750e-07 0.0000 8.020000e-07 0.0000 8.023750e-07 3.3000 8.420000e-07 3.3000 8.423750e-07 0.0000 9.220000e-07 0.0000 9.223750e-07 3.3000 1.002000e-06 3.3000 1.002375e-06 0.0000 1.042000e-06 0.0000 1.042375e-06 3.3000 1.082000e-06 3.3000 1.082375e-06 0.0000 1.122000e-06 0.0000 1.122375e-06 3.3000 1.162000e-06 3.3000 1.162375e-06 0.0000 1.202000e-06 0.0000 1.202375e-06 3.3000 1.362000e-06 3.3000 1.362375e-06 0.0000 1.482000e-06 0.0000 1.482375e-06 3.3000 1.522000e-06 3.3000 1.522375e-06 0.0000 1.562000e-06 0.0000 1.562375e-06 3.3000)
V_a_9 a_9 0 PWL(0.000000e+00 0.0000 8.200000e-08 0.0000 8.237500e-08 3.3000 2.020000e-07 3.3000 2.023750e-07 0.0000 2.820000e-07 0.0000 2.823750e-07 3.3000 3.620000e-07 3.3000 3.623750e-07 0.0000 4.420000e-07 0.0000 4.423750e-07 3.3000 5.220000e-07 3.3000 5.223750e-07 0.0000 5.620000e-07 0.0000 5.623750e-07 3.3000 6.020000e-07 3.3000 6.023750e-07 0.0000 6.420000e-07 0.0000 6.423750e-07 3.3000 6.820000e-07 3.3000 6.823750e-07 0.0000 7.220000e-07 0.0000 7.223750e-07 3.3000 7.620000e-07 3.3000 7.623750e-07 0.0000 8.020000e-07 0.0000 8.023750e-07 3.3000 8.420000e-07 3.3000 8.423750e-07 0.0000 9.620000e-07 0.0000 9.623750e-07 3.3000 1.042000e-06 3.3000 1.042375e-06 0.0000 1.122000e-06 0.0000 1.122375e-06 3.3000 1.162000e-06 3.3000 1.162375e-06 0.0000 1.202000e-06 0.0000 1.202375e-06 3.3000 1.322000e-06 3.3000 1.322375e-06 0.0000 1.362000e-06 0.0000 1.362375e-06 3.3000 1.482000e-06 3.3000 1.482375e-06 0.0000 1.562000e-06 0.0000 1.562375e-06 3.3000)
V_a_10 a_10 0 PWL(0.000000e+00 0.0000 4.200000e-08 0.0000 4.237500e-08 3.3000 8.200000e-08 3.3000 8.237500e-08 0.0000 1.220000e-07 0.0000 1.223750e-07 3.3000 2.420000e-07 3.3000 2.423750e-07 0.0000 2.820000e-07 0.0000 2.823750e-07 3.3000 3.220000e-07 3.3000 3.223750e-07 0.0000 4.420000e-07 0.0000 4.423750e-07 3.3000 5.620000e-07 3.3000 5.623750e-07 0.0000 6.020000e-07 0.0000 6.023750e-07 3.3000 6.420000e-07 3.3000 6.423750e-07 0.0000 8.420000e-07 0.0000 8.423750e-07 3.3000 9.620000e-07 3.3000 9.623750e-07 0.0000 1.002000e-06 0.0000 1.002375e-06 3.3000 1.042000e-06 3.3000 1.042375e-06 0.0000 1.082000e-06 0.0000 1.082375e-06 3.3000 1.162000e-06 3.3000 1.162375e-06 0.0000 1.242000e-06 0.0000 1.242375e-06 3.3000 1.322000e-06 3.3000 1.322375e-06 0.0000 1.362000e-06 0.0000 1.362375e-06 3.3000 1.442000e-06 3.3000 1.442375e-06 0.0000 1.482000e-06 0.0000 1.482375e-06 3.3000)
V_a_11 a_11 0 PWL(0.000000e+00 3.3000 4.200000e-08 3.3000 4.237500e-08 0.0000 2.020000e-07 0.0000 2.023750e-07 3.3000 2.420000e-07 3.3000 2.423750e-07 0.0000 3.220000e-07 0.0000 3.223750e-07 3.3000 3.620000e-07 3.3000 3.623750e-07 0.0000 4.020000e-07 0.0000 4.023750e-07 3.3000 6.020000e-07 3.3000 6.023750e-07 0.0000 6.420000e-07 0.0000 6.423750e-07 3.3000 8.020000e-07 3.3000 8.023750e-07 0.0000 8.420000e-07 0.0000 8.423750e-07 3.3000 8.820000e-07 3.3000 8.823750e-07 0.0000 9.220000e-07 0.0000 9.223750e-07 3.3000 1.082000e-06 3.3000 1.082375e-06 0.0000 1.162000e-06 0.0000 1.162375e-06 3.3000 1.202000e-06 3.3000 1.202375e-06 0.0000 1.242000e-06 0.0000 1.242375e-06 3.3000 1.522000e-06 3.3000 1.522375e-06 0.0000 1.642000e-06 0.0000 1.642375e-06 3.3000)
V_a_12 a_12 0 PWL(0.000000e+00 3.3000 4.200000e-08 3.3000 4.237500e-08 0.0000 1.620000e-07 0.0000 1.623750e-07 3.3000 2.420000e-07 3.3000 2.423750e-07 0.0000 3.620000e-07 0.0000 3.623750e-07 3.3000 4.020000e-07 3.3000 4.023750e-07 0.0000 5.620000e-07 0.0000 5.623750e-07 3.3000 6.020000e-07 3.3000 6.023750e-07 0.0000 6.420000e-07 0.0000 6.423750e-07 3.3000 6.820000e-07 3.3000 6.823750e-07 0.0000 7.220000e-07 0.0000 7.223750e-07 3.3000 8.020000e-07 3.3000 8.023750e-07 0.0000 8.420000e-07 0.0000 8.423750e-07 3.3000 8.820000e-07 3.3000 8.823750e-07 0.0000 9.220000e-07 0.0000 9.223750e-07 3.3000 9.620000e-07 3.3000 9.623750e-07 0.0000 1.002000e-06 0.0000 1.002375e-06 3.3000 1.082000e-06 3.3000 1.082375e-06 0.0000 1.122000e-06 0.0000 1.122375e-06 3.3000 1.162000e-06 3.3000 1.162375e-06 0.0000 1.322000e-06 0.0000 1.322375e-06 3.3000 1.362000e-06 3.3000 1.362375e-06 0.0000 1.442000e-06 0.0000 1.442375e-06 3.3000 1.522000e-06 3.3000 1.522375e-06 0.0000 1.562000e-06 0.0000 1.562375e-06 3.3000 1.602000e-06 3.3000 1.602375e-06 0.0000 1.642000e-06 0.0000 1.642375e-06 3.3000)
V_a_13 a_13 0 PWL(0.000000e+00 3.3000 4.200000e-08 3.3000 4.237500e-08 0.0000 8.200000e-08 0.0000 8.237500e-08 3.3000 1.220000e-07 3.3000 1.223750e-07 0.0000 1.620000e-07 0.0000 1.623750e-07 3.3000 2.420000e-07 3.3000 2.423750e-07 0.0000 2.820000e-07 0.0000 2.823750e-07 3.3000 4.020000e-07 3.3000 4.023750e-07 0.0000 4.820000e-07 0.0000 4.823750e-07 3.3000 6.020000e-07 3.3000 6.023750e-07 0.0000 6.420000e-07 0.0000 6.423750e-07 3.3000 6.820000e-07 3.3000 6.823750e-07 0.0000 7.220000e-07 0.0000 7.223750e-07 3.3000 7.620000e-07 3.3000 7.623750e-07 0.0000 8.020000e-07 0.0000 8.023750e-07 3.3000 8.820000e-07 3.3000 8.823750e-07 0.0000 1.002000e-06 0.0000 1.002375e-06 3.3000 1.122000e-06 3.3000 1.122375e-06 0.0000 1.162000e-06 0.0000 1.162375e-06 3.3000 1.202000e-06 3.3000 1.202375e-06 0.0000 1.242000e-06 0.0000 1.242375e-06 3.3000 1.362000e-06 3.3000 1.362375e-06 0.0000 1.442000e-06 0.0000 1.442375e-06 3.3000 1.522000e-06 3.3000 1.522375e-06 0.0000 1.562000e-06 0.0000 1.562375e-06 3.3000 1.602000e-06 3.3000 1.602375e-06 0.0000 1.642000e-06 0.0000 1.642375e-06 3.3000)
V_a_14 a_14 0 PWL(0.000000e+00 0.0000 4.200000e-08 0.0000 4.237500e-08 3.3000 8.200000e-08 3.3000 8.237500e-08 0.0000 2.420000e-07 0.0000 2.423750e-07 3.3000 3.220000e-07 3.3000 3.223750e-07 0.0000 4.020000e-07 0.0000 4.023750e-07 3.3000 5.220000e-07 3.3000 5.223750e-07 0.0000 5.620000e-07 0.0000 5.623750e-07 3.3000 6.020000e-07 3.3000 6.023750e-07 0.0000 8.020000e-07 0.0000 8.023750e-07 3.3000 8.420000e-07 3.3000 8.423750e-07 0.0000 1.042000e-06 0.0000 1.042375e-06 3.3000 1.082000e-06 3.3000 1.082375e-06 0.0000 1.122000e-06 0.0000 1.122375e-06 3.3000 1.242000e-06 3.3000 1.242375e-06 0.0000 1.322000e-06 0.0000 1.322375e-06 3.3000 1.362000e-06 3.3000 1.362375e-06 0.0000 1.482000e-06 0.0000 1.482375e-06 3.3000 1.562000e-06 3.3000 1.562375e-06 0.0000 1.642000e-06 0.0000 1.642375e-06 3.3000)
V_a_15 a_15 0 PWL(0.000000e+00 3.3000 4.200000e-08 3.3000 4.237500e-08 0.0000 8.200000e-08 0.0000 8.237500e-08 3.3000 1.220000e-07 3.3000 1.223750e-07 0.0000 1.620000e-07 0.0000 1.623750e-07 3.3000 2.820000e-07 3.3000 2.823750e-07 0.0000 4.820000e-07 0.0000 4.823750e-07 3.3000 5.220000e-07 3.3000 5.223750e-07 0.0000 5.620000e-07 0.0000 5.623750e-07 3.3000 6.420000e-07 3.3000 6.423750e-07 0.0000 6.820000e-07 0.0000 6.823750e-07 3.3000 7.220000e-07 3.3000 7.223750e-07 0.0000 7.620000e-07 0.0000 7.623750e-07 3.3000 8.420000e-07 3.3000 8.423750e-07 0.0000 9.220000e-07 0.0000 9.223750e-07 3.3000 1.042000e-06 3.3000 1.042375e-06 0.0000 1.122000e-06 0.0000 1.122375e-06 3.3000 1.602000e-06 3.3000 1.602375e-06 0.0000 1.642000e-06 0.0000 1.642375e-06 3.3000)
V_a_16 a_16 0 PWL(0.000000e+00 0.0000 4.200000e-08 0.0000 4.237500e-08 3.3000 8.200000e-08 3.3000 8.237500e-08 0.0000 1.620000e-07 0.0000 1.623750e-07 3.3000 3.620000e-07 3.3000 3.623750e-07 0.0000 4.420000e-07 0.0000 4.423750e-07 3.3000 4.820000e-07 3.3000 4.823750e-07 0.0000 5.220000e-07 0.0000 5.223750e-07 3.3000 5.620000e-07 3.3000 5.623750e-07 0.0000 6.420000e-07 0.0000 6.423750e-07 3.3000 6.820000e-07 3.3000 6.823750e-07 0.0000 9.220000e-07 0.0000 9.223750e-07 3.3000 1.122000e-06 3.3000 1.122375e-06 0.0000 1.162000e-06 0.0000 1.162375e-06 3.3000 1.202000e-06 3.3000 1.202375e-06 0.0000 1.242000e-06 0.0000 1.242375e-06 3.3000 1.282000e-06 3.3000 1.282375e-06 0.0000 1.362000e-06 0.0000 1.362375e-06 3.3000 1.402000e-06 3.3000 1.402375e-06 0.0000 1.442000e-06 0.0000 1.442375e-06 3.3000 1.482000e-06 3.3000 1.482375e-06 0.0000 1.562000e-06 0.0000 1.562375e-06 3.3000 1.602000e-06 3.3000 1.602375e-06 0.0000 1.642000e-06 0.0000 1.642375e-06 3.3000)
V_a_17 a_17 0 PWL(0.000000e+00 0.0000 1.220000e-07 0.0000 1.223750e-07 3.3000 2.020000e-07 3.3000 2.023750e-07 0.0000 2.420000e-07 0.0000 2.423750e-07 3.3000 3.620000e-07 3.3000 3.623750e-07 0.0000 4.020000e-07 0.0000 4.023750e-07 3.3000 4.420000e-07 3.3000 4.423750e-07 0.0000 5.220000e-07 0.0000 5.223750e-07 3.3000 6.020000e-07 3.3000 6.023750e-07 0.0000 7.620000e-07 0.0000 7.623750e-07 3.3000 8.020000e-07 3.3000 8.023750e-07 0.0000 8.420000e-07 0.0000 8.423750e-07 3.3000 8.820000e-07 3.3000 8.823750e-07 0.0000 9.220000e-07 0.0000 9.223750e-07 3.3000 1.002000e-06 3.3000 1.002375e-06 0.0000 1.082000e-06 0.0000 1.082375e-06 3.3000 1.162000e-06 3.3000 1.162375e-06 0.0000 1.242000e-06 0.0000 1.242375e-06 3.3000 1.442000e-06 3.3000 1.442375e-06 0.0000 1.482000e-06 0.0000 1.482375e-06 3.3000 1.602000e-06 3.3000 1.602375e-06 0.0000 1.642000e-06 0.0000 1.642375e-06 3.3000)
V_a_18 a_18 0 PWL(0.000000e+00 3.3000 4.200000e-08 3.3000 4.237500e-08 0.0000 8.200000e-08 0.0000 8.237500e-08 3.3000 1.620000e-07 3.3000 1.623750e-07 0.0000 2.020000e-07 0.0000 2.023750e-07 3.3000 2.420000e-07 3.3000 2.423750e-07 0.0000 2.820000e-07 0.0000 2.823750e-07 3.3000 3.220000e-07 3.3000 3.223750e-07 0.0000 3.620000e-07 0.0000 3.623750e-07 3.3000 5.220000e-07 3.3000 5.223750e-07 0.0000 6.820000e-07 0.0000 6.823750e-07 3.3000 8.020000e-07 3.3000 8.023750e-07 0.0000 8.420000e-07 0.0000 8.423750e-07 3.3000 9.620000e-07 3.3000 9.623750e-07 0.0000 1.042000e-06 0.0000 1.042375e-06 3.3000 1.122000e-06 3.3000 1.122375e-06 0.0000 1.202000e-06 0.0000 1.202375e-06 3.3000 1.402000e-06 3.3000 1.402375e-06 0.0000 1.642000e-06 0.0000 1.642375e-06 3.3000)
V_a_19 a_19 0 PWL(0.000000e+00 0.0000 4.200000e-08 0.0000 4.237500e-08 3.3000 8.200000e-08 3.3000 8.237500e-08 0.0000 2.020000e-07 0.0000 2.023750e-07 3.3000 3.620000e-07 3.3000 3.623750e-07 0.0000 4.020000e-07 0.0000 4.023750e-07 3.3000 4.420000e-07 3.3000 4.423750e-07 0.0000 6.020000e-07 0.0000 6.023750e-07 3.3000 6.820000e-07 3.3000 6.823750e-07 0.0000 8.020000e-07 0.0000 8.023750e-07 3.3000 8.420000e-07 3.3000 8.423750e-07 0.0000 9.620000e-07 0.0000 9.623750e-07 3.3000 1.002000e-06 3.3000 1.002375e-06 0.0000 1.242000e-06 0.0000 1.242375e-06 3.3000 1.322000e-06 3.3000 1.322375e-06 0.0000 1.402000e-06 0.0000 1.402375e-06 3.3000 1.562000e-06 3.3000 1.562375e-06 0.0000 1.602000e-06 0.0000 1.602375e-06 3.3000)
V_a_20 a_20 0 PWL(0.000000e+00 3.3000 8.200000e-08 3.3000 8.237500e-08 0.0000 2.420000e-07 0.0000 2.423750e-07 3.3000 2.820000e-07 3.3000 2.823750e-07 0.0000 3.220000e-07 0.0000 3.223750e-07 3.3000 3.620000e-07 3.3000 3.623750e-07 0.0000 7.220000e-07 0.0000 7.223750e-07 3.3000 7.620000e-07 3.3000 7.623750e-07 0.0000 1.002000e-06 0.0000 1.002375e-06 3.3000 1.042000e-06 3.3000 1.042375e-06 0.0000 1.082000e-06 0.0000 1.082375e-06 3.3000 1.202000e-06 3.3000 1.202375e-06 0.0000 1.242000e-06 0.0000 1.242375e-06 3.3000 1.282000e-06 3.3000 1.282375e-06 0.0000 1.482000e-06 0.0000 1.482375e-06 3.3000 1.522000e-06 3.3000 1.522375e-06 0.0000 1.602000e-06 0.0000 1.602375e-06 3.3000)
V_a_21 a_21 0 PWL(0.000000e+00 0.0000 3.620000e-07 0.0000 3.623750e-07 3.3000 4.020000e-07 3.3000 4.023750e-07 0.0000 4.420000e-07 0.0000 4.423750e-07 3.3000 5.220000e-07 3.3000 5.223750e-07 0.0000 6.820000e-07 0.0000 6.823750e-07 3.3000 7.620000e-07 3.3000 7.623750e-07 0.0000 8.020000e-07 0.0000 8.023750e-07 3.3000 8.420000e-07 3.3000 8.423750e-07 0.0000 9.220000e-07 0.0000 9.223750e-07 3.3000 1.082000e-06 3.3000 1.082375e-06 0.0000 1.122000e-06 0.0000 1.122375e-06 3.3000 1.242000e-06 3.3000 1.242375e-06 0.0000 1.282000e-06 0.0000 1.282375e-06 3.3000 1.362000e-06 3.3000 1.362375e-06 0.0000 1.522000e-06 0.0000 1.522375e-06 3.3000)
V_b_0 b_0 0 PWL(0.000000e+00 3.3000 8.200000e-08 3.3000 8.237500e-08 0.0000 1.620000e-07 0.0000 1.623750e-07 3.3000 2.020000e-07 3.3000 2.023750e-07 0.0000 2.420000e-07 0.0000 2.423750e-07 3.3000 4.020000e-07 3.3000 4.023750e-07 0.0000 4.420000e-07 0.0000 4.423750e-07 3.3000 4.820000e-07 3.3000 4.823750e-07 0.0000 5.620000e-07 0.0000 5.623750e-07 3.3000 6.420000e-07 3.3000 6.423750e-07 0.0000 7.620000e-07 0.0000 7.623750e-07 3.3000 8.020000e-07 3.3000 8.023750e-07 0.0000 9.220000e-07 0.0000 9.223750e-07 3.3000 9.620000e-07 3.3000 9.623750e-07 0.0000 1.042000e-06 0.0000 1.042375e-06 3.3000 1.122000e-06 3.3000 1.122375e-06 0.0000 1.282000e-06 0.0000 1.282375e-06 3.3000 1.442000e-06 3.3000 1.442375e-06 0.0000 1.482000e-06 0.0000 1.482375e-06 3.3000 1.562000e-06 3.3000 1.562375e-06 0.0000)
V_b_1 b_1 0 PWL(0.000000e+00 3.3000 4.200000e-08 3.3000 4.237500e-08 0.0000 8.200000e-08 0.0000 8.237500e-08 3.3000 2.020000e-07 3.3000 2.023750e-07 0.0000 3.220000e-07 0.0000 3.223750e-07 3.3000 4.020000e-07 3.3000 4.023750e-07 0.0000 4.420000e-07 0.0000 4.423750e-07 3.3000 5.620000e-07 3.3000 5.623750e-07 0.0000 6.820000e-07 0.0000 6.823750e-07 3.3000 8.020000e-07 3.3000 8.023750e-07 0.0000 8.420000e-07 0.0000 8.423750e-07 3.3000 8.820000e-07 3.3000 8.823750e-07 0.0000 1.162000e-06 0.0000 1.162375e-06 3.3000 1.202000e-06 3.3000 1.202375e-06 0.0000 1.282000e-06 0.0000 1.282375e-06 3.3000 1.362000e-06 3.3000 1.362375e-06 0.0000 1.402000e-06 0.0000 1.402375e-06 3.3000 1.562000e-06 3.3000 1.562375e-06 0.0000 1.602000e-06 0.0000 1.602375e-06 3.3000 1.642000e-06 3.3000 1.642375e-06 0.0000)
V_b_2 b_2 0 PWL(0.000000e+00 0.0000 1.620000e-07 0.0000 1.623750e-07 3.3000 4.420000e-07 3.3000 4.423750e-07 0.0000 5.220000e-07 0.0000 5.223750e-07 3.3000 6.420000e-07 3.3000 6.423750e-07 0.0000 7.220000e-07 0.0000 7.223750e-07 3.3000 1.042000e-06 3.3000 1.042375e-06 0.0000 1.122000e-06 0.0000 1.122375e-06 3.3000 1.202000e-06 3.3000 1.202375e-06 0.0000 1.322000e-06 0.0000 1.322375e-06 3.3000 1.362000e-06 3.3000 1.362375e-06 0.0000 1.402000e-06 0.0000 1.402375e-06 3.3000 1.442000e-06 3.3000 1.442375e-06 0.0000 1.482000e-06 0.0000 1.482375e-06 3.3000 1.522000e-06 3.3000 1.522375e-06 0.0000 1.562000e-06 0.0000 1.562375e-06 3.3000 1.642000e-06 3.3000 1.642375e-06 0.0000)
V_b_3 b_3 0 PWL(0.000000e+00 0.0000 4.200000e-08 0.0000 4.237500e-08 3.3000 8.200000e-08 3.3000 8.237500e-08 0.0000 2.820000e-07 0.0000 2.823750e-07 3.3000 3.220000e-07 3.3000 3.223750e-07 0.0000 3.620000e-07 0.0000 3.623750e-07 3.3000 4.420000e-07 3.3000 4.423750e-07 0.0000 6.420000e-07 0.0000 6.423750e-07 3.3000 8.020000e-07 3.3000 8.023750e-07 0.0000 8.420000e-07 0.0000 8.423750e-07 3.3000 9.620000e-07 3.3000 9.623750e-07 0.0000 1.002000e-06 0.0000 1.002375e-06 3.3000 1.082000e-06 3.3000 1.082375e-06 0.0000 1.122000e-06 0.0000 1.122375e-06 3.3000 1.162000e-06 3.3000 1.162375e-06 0.0000 1.202000e-06 0.0000 1.202375e-06 3.3000 1.242000e-06 3.3000 1.242375e-06 0.0000 1.322000e-06 0.0000 1.322375e-06 3.3000 1.362000e-06 3.3000 1.362375e-06 0.0000 1.402000e-06 0.0000 1.402375e-06 3.3000 1.442000e-06 3.3000 1.442375e-06 0.0000 1.482000e-06 0.0000 1.482375e-06 3.3000 1.562000e-06 3.3000 1.562375e-06 0.0000)
V_b_4 b_4 0 PWL(0.000000e+00 3.3000 4.200000e-08 3.3000 4.237500e-08 0.0000 1.220000e-07 0.0000 1.223750e-07 3.3000 4.020000e-07 3.3000 4.023750e-07 0.0000 5.220000e-07 0.0000 5.223750e-07 3.3000 5.620000e-07 3.3000 5.623750e-07 0.0000 6.020000e-07 0.0000 6.023750e-07 3.3000 6.820000e-07 3.3000 6.823750e-07 0.0000 8.020000e-07 0.0000 8.023750e-07 3.3000 9.220000e-07 3.3000 9.223750e-07 0.0000 9.620000e-07 0.0000 9.623750e-07 3.3000 1.042000e-06 3.3000 1.042375e-06 0.0000 1.282000e-06 0.0000 1.282375e-06 3.3000 1.322000e-06 3.3000 1.322375e-06 0.0000 1.402000e-06 0.0000 1.402375e-06 3.3000 1.602000e-06 3.3000 1.602375e-06 0.0000)
V_b_5 b_5 0 PWL(0.000000e+00 0.0000 4.200000e-08 0.0000 4.237500e-08 3.3000 8.200000e-08 3.3000 8.237500e-08 0.0000 1.220000e-07 0.0000 1.223750e-07 3.3000 1.620000e-07 3.3000 1.623750e-07 0.0000 2.820000e-07 0.0000 2.823750e-07 3.3000 3.620000e-07 3.3000 3.623750e-07 0.0000 4.020000e-07 0.0000 4.023750e-07 3.3000 4.420000e-07 3.3000 4.423750e-07 0.0000 5.220000e-07 0.0000 5.223750e-07 3.3000 6.420000e-07 3.3000 6.423750e-07 0.0000 6.820000e-07 0.0000 6.823750e-07 3.3000 8.020000e-07 3.3000 8.023750e-07 0.0000 8.420000e-07 0.0000 8.423750e-07 3.3000 8.820000e-07 3.3000 8.823750e-07 0.0000 9.220000e-07 0.0000 9.223750e-07 3.3000 1.122000e-06 3.3000 1.122375e-06 0.0000 1.282000e-06 0.0000 1.282375e-06 3.3000 1.362000e-06 3.3000 1.362375e-06 0.0000 1.402000e-06 0.0000 1.402375e-06 3.3000 1.482000e-06 3.3000 1.482375e-06 0.0000 1.522000e-06 0.0000 1.522375e-06 3.3000 1.642000e-06 3.3000 1.642375e-06 0.0000)
V_b_6 b_6 0 PWL(0.000000e+00 3.3000 1.620000e-07 3.3000 1.623750e-07 0.0000 2.020000e-07 0.0000 2.023750e-07 3.3000 2.820000e-07 3.3000 2.823750e-07 0.0000 3.220000e-07 0.0000 3.223750e-07 3.3000 4.020000e-07 3.3000 4.023750e-07 0.0000 4.420000e-07 0.0000 4.423750e-07 3.3000 4.820000e-07 3.3000 4.823750e-07 0.0000 5.220000e-07 0.0000 5.223750e-07 3.3000 6.420000e-07 3.3000 6.423750e-07 0.0000 7.220000e-07 0.0000 7.223750e-07 3.3000 8.020000e-07 3.3000 8.023750e-07 0.0000 9.220000e-07 0.0000 9.223750e-07 3.3000 9.620000e-07 3.3000 9.623750e-07 0.0000 1.002000e-06 0.0000 1.002375e-06 3.3000 1.042000e-06 3.3000 1.042375e-06 0.0000 1.082000e-06 0.0000 1.082375e-06 3.3000 1.282000e-06 3.3000 1.282375e-06 0.0000 1.402000e-06 0.0000 1.402375e-06 3.3000 1.442000e-06 3.3000 1.442375e-06 0.0000 1.482000e-06 0.0000 1.482375e-06 3.3000 1.522000e-06 3.3000 1.522375e-06 0.0000 1.562000e-06 0.0000 1.562375e-06 3.3000 1.642000e-06 3.3000 1.642375e-06 0.0000)
V_b_7 b_7 0 PWL(0.000000e+00 3.3000 1.220000e-07 3.3000 1.223750e-07 0.0000 1.620000e-07 0.0000 1.623750e-07 3.3000 2.020000e-07 3.3000 2.023750e-07 0.0000 4.820000e-07 0.0000 4.823750e-07 3.3000 5.620000e-07 3.3000 5.623750e-07 0.0000 6.020000e-07 0.0000 6.023750e-07 3.3000 6.820000e-07 3.3000 6.823750e-07 0.0000 7.220000e-07 0.0000 7.223750e-07 3.3000 8.020000e-07 3.3000 8.023750e-07 0.0000 8.820000e-07 0.0000 8.823750e-07 3.3000 9.220000e-07 3.3000 9.223750e-07 0.0000 9.620000e-07 0.0000 9.623750e-07 3.3000 1.082000e-06 3.3000 1.082375e-06 0.0000 1.282000e-06 0.0000 1.282375e-06 3.3000 1.322000e-06 3.3000 1.322375e-06 0.0000 1.362000e-06 0.0000 1.362375e-06 3.3000 1.482000e-06 3.3000 1.482375e-06 0.0000 1.522000e-06 0.0000 1.522375e-06 3.3000 1.562000e-06 3.3000 1.562375e-06 0.0000 1.602000e-06 0.0000 1.602375e-06 3.3000 1.642000e-06 3.3000 1.642375e-06 0.0000)
V_b_8 b_8 0 PWL(0.000000e+00 3.3000 4.200000e-08 3.3000 4.237500e-08 0.0000 8.200000e-08 0.0000 8.237500e-08 3.3000 1.620000e-07 3.3000 1.623750e-07 0.0000 2.420000e-07 0.0000 2.423750e-07 3.3000 2.820000e-07 3.3000 2.823750e-07 0.0000 4.420000e-07 0.0000 4.423750e-07 3.3000 5.220000e-07 3.3000 5.223750e-07 0.0000 7.220000e-07 0.0000 7.223750e-07 3.3000 7.620000e-07 3.3000 7.623750e-07 0.0000 9.620000e-07 0.0000 9.623750e-07 3.3000 1.002000e-06 3.3000 1.002375e-06 0.0000 1.042000e-06 0.0000 1.042375e-06 3.3000 1.242000e-06 3.3000 1.242375e-06 0.0000 1.282000e-06 0.0000 1.282375e-06 3.3000 1.402000e-06 3.3000 1.402375e-06 0.0000 1.522000e-06 0.0000 1.522375e-06 3.3000 1.562000e-06 3.3000 1.562375e-06 0.0000 1.602000e-06 0.0000 1.602375e-06 3.3000 1.642000e-06 3.3000 1.642375e-06 0.0000)
V_b_9 b_9 0 PWL(0.000000e+00 0.0000 8.200000e-08 0.0000 8.237500e-08 3.3000 1.620000e-07 3.3000 1.623750e-07 0.0000 2.020000e-07 0.0000 2.023750e-07 3.3000 3.220000e-07 3.3000 3.223750e-07 0.0000 4.420000e-07 0.0000 4.423750e-07 3.3000 4.820000e-07 3.3000 4.823750e-07 0.0000 5.220000e-07 0.0000 5.223750e-07 3.3000 5.620000e-07 3.3000 5.623750e-07 0.0000 6.420000e-07 0.0000 6.423750e-07 3.3000 7.220000e-07 3.3000 7.223750e-07 0.0000 8.020000e-07 0.0000 8.023750e-07 3.3000 1.042000e-06 3.3000 1.042375e-06 0.0000 1.082000e-06 0.0000 1.082375e-06 3.3000 1.122000e-06 3.3000 1.122375e-06 0.0000 1.162000e-06 0.0000 1.162375e-06 3.3000 1.282000e-06 3.3000 1.282375e-06 0.0000 1.322000e-06 0.0000 1.322375e-06 3.3000 1.402000e-06 3.3000 1.402375e-06 0.0000 1.442000e-06 0.0000 1.442375e-06 3.3000 1.562000e-06 3.3000 1.562375e-06 0.0000 1.602000e-06 0.0000 1.602375e-06 3.3000 1.642000e-06 3.3000 1.642375e-06 0.0000)
V_b_10 b_10 0 PWL(0.000000e+00 0.0000 8.200000e-08 0.0000 8.237500e-08 3.3000 1.620000e-07 3.3000 1.623750e-07 0.0000 2.020000e-07 0.0000 2.023750e-07 3.3000 2.420000e-07 3.3000 2.423750e-07 0.0000 2.820000e-07 0.0000 2.823750e-07 3.3000 3.220000e-07 3.3000 3.223750e-07 0.0000 3.620000e-07 0.0000 3.623750e-07 3.3000 4.820000e-07 3.3000 4.823750e-07 0.0000 6.820000e-07 0.0000 6.823750e-07 3.3000 7.620000e-07 3.3000 7.623750e-07 0.0000 8.020000e-07 0.0000 8.023750e-07 3.3000 1.002000e-06 3.3000 1.002375e-06 0.0000 1.082000e-06 0.0000 1.082375e-06 3.3000 1.122000e-06 3.3000 1.122375e-06 0.0000 1.162000e-06 0.0000 1.162375e-06 3.3000 1.242000e-06 3.3000 1.242375e-06 0.0000 1.402000e-06 0.0000 1.402375e-06 3.3000 1.442000e-06 3.3000 1.442375e-06 0.0000 1.522000e-06 0.0000 1.522375e-06 3.3000 1.642000e-06 3.3000 1.642375e-06 0.0000)
V_b_11 b_11 0 PWL(0.000000e+00 3.3000 1.220000e-07 3.3000 1.223750e-07 0.0000 1.620000e-07 0.0000 1.623750e-07 3.3000 2.020000e-07 3.3000 2.023750e-07 0.0000 2.820000e-07 0.0000 2.823750e-07 3.3000 4.420000e-07 3.3000 4.423750e-07 0.0000 4.820000e-07 0.0000 4.823750e-07 3.3000 5.620000e-07 3.3000 5.623750e-07 0.0000 6.020000e-07 0.0000 6.023750e-07 3.3000 7.220000e-07 3.3000 7.223750e-07 0.0000 7.620000e-07 0.0000 7.623750e-07 3.3000 8.020000e-07 3.3000 8.023750e-07 0.0000 8.420000e-07 0.0000 8.423750e-07 3.3000 9.620000e-07 3.3000 9.623750e-07 0.0000 1.002000e-06 0.0000 1.002375e-06 3.3000 1.122000e-06 3.3000 1.122375e-06 0.0000 1.162000e-06 0.0000 1.162375e-06 3.3000 1.202000e-06 3.3000 1.202375e-06 0.0000 1.282000e-06 0.0000 1.282375e-06 3.3000 1.362000e-06 3.3000 1.362375e-06 0.0000 1.442000e-06 0.0000 1.442375e-06 3.3000 1.482000e-06 3.3000 1.482375e-06 0.0000 1.562000e-06 0.0000 1.562375e-06 3.3000 1.642000e-06 3.3000 1.642375e-06 0.0000)
V_b_12 b_12 0 PWL(0.000000e+00 0.0000 1.620000e-07 0.0000 1.623750e-07 3.3000 2.020000e-07 3.3000 2.023750e-07 0.0000 4.020000e-07 0.0000 4.023750e-07 3.3000 4.420000e-07 3.3000 4.423750e-07 0.0000 4.820000e-07 0.0000 4.823750e-07 3.3000 5.620000e-07 3.3000 5.623750e-07 0.0000 6.420000e-07 0.0000 6.423750e-07 3.3000 7.220000e-07 3.3000 7.223750e-07 0.0000 7.620000e-07 0.0000 7.623750e-07 3.3000 8.020000e-07 3.3000 8.023750e-07 0.0000 8.820000e-07 0.0000 8.823750e-07 3.3000 9.220000e-07 3.3000 9.223750e-07 0.0000 1.002000e-06 0.0000 1.002375e-06 3.3000 1.082000e-06 3.3000 1.082375e-06 0.0000 1.162000e-06 0.0000 1.162375e-06 3.3000 1.242000e-06 3.3000 1.242375e-06 0.0000 1.282000e-06 0.0000 1.282375e-06 3.3000 1.362000e-06 3.3000 1.362375e-06 0.0000 1.402000e-06 0.0000 1.402375e-06 3.3000 1.482000e-06 3.3000 1.482375e-06 0.0000 1.522000e-06 0.0000 1.522375e-06 3.3000 1.562000e-06 3.3000 1.562375e-06 0.0000 1.602000e-06 0.0000 1.602375e-06 3.3000 1.642000e-06 3.3000 1.642375e-06 0.0000)
V_b_13 b_13 0 PWL(0.000000e+00 3.3000 8.200000e-08 3.3000 8.237500e-08 0.0000 1.220000e-07 0.0000 1.223750e-07 3.3000 2.420000e-07 3.3000 2.423750e-07 0.0000 3.620000e-07 0.0000 3.623750e-07 3.3000 4.020000e-07 3.3000 4.023750e-07 0.0000 4.420000e-07 0.0000 4.423750e-07 3.3000 6.020000e-07 3.3000 6.023750e-07 0.0000 6.820000e-07 0.0000 6.823750e-07 3.3000 8.020000e-07 3.3000 8.023750e-07 0.0000 9.220000e-07 0.0000 9.223750e-07 3.3000 9.620000e-07 3.3000 9.623750e-07 0.0000 1.082000e-06 0.0000 1.082375e-06 3.3000 1.122000e-06 3.3000 1.122375e-06 0.0000 1.202000e-06 0.0000 1.202375e-06 3.3000 1.242000e-06 3.3000 1.242375e-06 0.0000 1.282000e-06 0.0000 1.282375e-06 3.3000 1.362000e-06 3.3000 1.362375e-06 0.0000 1.402000e-06 0.0000 1.402375e-06 3.3000 1.482000e-06 3.3000 1.482375e-06 0.0000 1.522000e-06 0.0000 1.522375e-06 3.3000 1.602000e-06 3.3000 1.602375e-06 0.0000)
V_b_14 b_14 0 PWL(0.000000e+00 0.0000 1.220000e-07 0.0000 1.223750e-07 3.3000 1.620000e-07 3.3000 1.623750e-07 0.0000 2.020000e-07 0.0000 2.023750e-07 3.3000 4.420000e-07 3.3000 4.423750e-07 0.0000 4.820000e-07 0.0000 4.823750e-07 3.3000 5.620000e-07 3.3000 5.623750e-07 0.0000 1.362000e-06 0.0000 1.362375e-06 3.3000 1.442000e-06 3.3000 1.442375e-06 0.0000 1.522000e-06 0.0000 1.522375e-06 3.3000 1.562000e-06 3.3000 1.562375e-06 0.0000 1.602000e-06 0.0000 1.602375e-06 3.3000 1.642000e-06 3.3000 1.642375e-06 0.0000)
V_b_15 b_15 0 PWL(0.000000e+00 3.3000 1.220000e-07 3.3000 1.223750e-07 0.0000 2.420000e-07 0.0000 2.423750e-07 3.3000 4.020000e-07 3.3000 4.023750e-07 0.0000 4.420000e-07 0.0000 4.423750e-07 3.3000 4.820000e-07 3.3000 4.823750e-07 0.0000 5.620000e-07 0.0000 5.623750e-07 3.3000 7.620000e-07 3.3000 7.623750e-07 0.0000 1.122000e-06 0.0000 1.122375e-06 3.3000 1.202000e-06 3.3000 1.202375e-06 0.0000 1.282000e-06 0.0000 1.282375e-06 3.3000 1.402000e-06 3.3000 1.402375e-06 0.0000 1.442000e-06 0.0000 1.442375e-06 3.3000 1.602000e-06 3.3000 1.602375e-06 0.0000)
V_b_16 b_16 0 PWL(0.000000e+00 0.0000 4.200000e-08 0.0000 4.237500e-08 3.3000 8.200000e-08 3.3000 8.237500e-08 0.0000 1.220000e-07 0.0000 1.223750e-07 3.3000 1.620000e-07 3.3000 1.623750e-07 0.0000 2.820000e-07 0.0000 2.823750e-07 3.3000 4.020000e-07 3.3000 4.023750e-07 0.0000 4.820000e-07 0.0000 4.823750e-07 3.3000 5.220000e-07 3.3000 5.223750e-07 0.0000 5.620000e-07 0.0000 5.623750e-07 3.3000 6.020000e-07 3.3000 6.023750e-07 0.0000 6.820000e-07 0.0000 6.823750e-07 3.3000 8.020000e-07 3.3000 8.023750e-07 0.0000 8.420000e-07 0.0000 8.423750e-07 3.3000 8.820000e-07 3.3000 8.823750e-07 0.0000 9.220000e-07 0.0000 9.223750e-07 3.3000 9.620000e-07 3.3000 9.623750e-07 0.0000 1.042000e-06 0.0000 1.042375e-06 3.3000 1.242000e-06 3.3000 1.242375e-06 0.0000 1.442000e-06 0.0000 1.442375e-06 3.3000 1.482000e-06 3.3000 1.482375e-06 0.0000)
V_b_17 b_17 0 PWL(0.000000e+00 0.0000 1.220000e-07 0.0000 1.223750e-07 3.3000 2.820000e-07 3.3000 2.823750e-07 0.0000 3.220000e-07 0.0000 3.223750e-07 3.3000 4.020000e-07 3.3000 4.023750e-07 0.0000 5.220000e-07 0.0000 5.223750e-07 3.3000 7.620000e-07 3.3000 7.623750e-07 0.0000 8.420000e-07 0.0000 8.423750e-07 3.3000 8.820000e-07 3.3000 8.823750e-07 0.0000 9.620000e-07 0.0000 9.623750e-07 3.3000 1.002000e-06 3.3000 1.002375e-06 0.0000 1.042000e-06 0.0000 1.042375e-06 3.3000 1.242000e-06 3.3000 1.242375e-06 0.0000 1.322000e-06 0.0000 1.322375e-06 3.3000 1.362000e-06 3.3000 1.362375e-06 0.0000 1.442000e-06 0.0000 1.442375e-06 3.3000 1.522000e-06 3.3000 1.522375e-06 0.0000)
V_b_18 b_18 0 PWL(0.000000e+00 3.3000 4.200000e-08 3.3000 4.237500e-08 0.0000 8.200000e-08 0.0000 8.237500e-08 3.3000 1.620000e-07 3.3000 1.623750e-07 0.0000 2.820000e-07 0.0000 2.823750e-07 3.3000 3.220000e-07 3.3000 3.223750e-07 0.0000 3.620000e-07 0.0000 3.623750e-07 3.3000 4.020000e-07 3.3000 4.023750e-07 0.0000 4.420000e-07 0.0000 4.423750e-07 3.3000 5.620000e-07 3.3000 5.623750e-07 0.0000 7.620000e-07 0.0000 7.623750e-07 3.3000 8.420000e-07 3.3000 8.423750e-07 0.0000 8.820000e-07 0.0000 8.823750e-07 3.3000 9.620000e-07 3.3000 9.623750e-07 0.0000 1.002000e-06 0.0000 1.002375e-06 3.3000 1.042000e-06 3.3000 1.042375e-06 0.0000 1.162000e-06 0.0000 1.162375e-06 3.3000 1.202000e-06 3.3000 1.202375e-06 0.0000 1.282000e-06 0.0000 1.282375e-06 3.3000 1.362000e-06 3.3000 1.362375e-06 0.0000 1.522000e-06 0.0000 1.522375e-06 3.3000 1.642000e-06 3.3000 1.642375e-06 0.0000)
V_b_19 b_19 0 PWL(0.000000e+00 3.3000 8.200000e-08 3.3000 8.237500e-08 0.0000 1.620000e-07 0.0000 1.623750e-07 3.3000 2.020000e-07 3.3000 2.023750e-07 0.0000 2.420000e-07 0.0000 2.423750e-07 3.3000 2.820000e-07 3.3000 2.823750e-07 0.0000 4.020000e-07 0.0000 4.023750e-07 3.3000 4.820000e-07 3.3000 4.823750e-07 0.0000 5.220000e-07 0.0000 5.223750e-07 3.3000 5.620000e-07 3.3000 5.623750e-07 0.0000 7.220000e-07 0.0000 7.223750e-07 3.3000 7.620000e-07 3.3000 7.623750e-07 0.0000 8.020000e-07 0.0000 8.023750e-07 3.3000 8.420000e-07 3.3000 8.423750e-07 0.0000 9.220000e-07 0.0000 9.223750e-07 3.3000 9.620000e-07 3.3000 9.623750e-07 0.0000 1.042000e-06 0.0000 1.042375e-06 3.3000 1.082000e-06 3.3000 1.082375e-06 0.0000 1.122000e-06 0.0000 1.122375e-06 3.3000 1.202000e-06 3.3000 1.202375e-06 0.0000 1.242000e-06 0.0000 1.242375e-06 3.3000 1.362000e-06 3.3000 1.362375e-06 0.0000 1.442000e-06 0.0000 1.442375e-06 3.3000 1.482000e-06 3.3000 1.482375e-06 0.0000)
V_b_20 b_20 0 PWL(0.000000e+00 3.3000 4.200000e-08 3.3000 4.237500e-08 0.0000 8.200000e-08 0.0000 8.237500e-08 3.3000 2.020000e-07 3.3000 2.023750e-07 0.0000 2.420000e-07 0.0000 2.423750e-07 3.3000 2.820000e-07 3.3000 2.823750e-07 0.0000 4.420000e-07 0.0000 4.423750e-07 3.3000 4.820000e-07 3.3000 4.823750e-07 0.0000 5.220000e-07 0.0000 5.223750e-07 3.3000 5.620000e-07 3.3000 5.623750e-07 0.0000 6.020000e-07 0.0000 6.023750e-07 3.3000 6.420000e-07 3.3000 6.423750e-07 0.0000 6.820000e-07 0.0000 6.823750e-07 3.3000 7.220000e-07 3.3000 7.223750e-07 0.0000 1.002000e-06 0.0000 1.002375e-06 3.3000 1.122000e-06 3.3000 1.122375e-06 0.0000 1.202000e-06 0.0000 1.202375e-06 3.3000 1.362000e-06 3.3000 1.362375e-06 0.0000 1.402000e-06 0.0000 1.402375e-06 3.3000 1.482000e-06 3.3000 1.482375e-06 0.0000 1.602000e-06 0.0000 1.602375e-06 3.3000 1.642000e-06 3.3000 1.642375e-06 0.0000)
V_b_21 b_21 0 PWL(0.000000e+00 3.3000 1.220000e-07 3.3000 1.223750e-07 0.0000 1.620000e-07 0.0000 1.623750e-07 3.3000 2.020000e-07 3.3000 2.023750e-07 0.0000 4.020000e-07 0.0000 4.023750e-07 3.3000 6.020000e-07 3.3000 6.023750e-07 0.0000 6.420000e-07 0.0000 6.423750e-07 3.3000 6.820000e-07 3.3000 6.823750e-07 0.0000 7.220000e-07 0.0000 7.223750e-07 3.3000 8.020000e-07 3.3000 8.023750e-07 0.0000 8.420000e-07 0.0000 8.423750e-07 3.3000 9.220000e-07 3.3000 9.223750e-07 0.0000 9.620000e-07 0.0000 9.623750e-07 3.3000 1.002000e-06 3.3000 1.002375e-06 0.0000 1.042000e-06 0.0000 1.042375e-06 3.3000 1.082000e-06 3.3000 1.082375e-06 0.0000 1.242000e-06 0.0000 1.242375e-06 3.3000 1.282000e-06 3.3000 1.282375e-06 0.0000 1.322000e-06 0.0000 1.322375e-06 3.3000 1.482000e-06 3.3000 1.482375e-06 0.0000 1.562000e-06 0.0000 1.562375e-06 3.3000 1.642000e-06 3.3000 1.642375e-06 0.0000)
V_cin cin 0 PWL(0.000000e+00 0.0000 8.200000e-08 0.0000 8.237500e-08 3.3000 2.020000e-07 3.3000 2.023750e-07 0.0000 2.820000e-07 0.0000 2.823750e-07 3.3000 4.420000e-07 3.3000 4.423750e-07 0.0000 5.620000e-07 0.0000 5.623750e-07 3.3000 6.020000e-07 3.3000 6.023750e-07 0.0000 6.820000e-07 0.0000 6.823750e-07 3.3000 7.220000e-07 3.3000 7.223750e-07 0.0000 7.620000e-07 0.0000 7.623750e-07 3.3000 8.020000e-07 3.3000 8.023750e-07 0.0000 8.420000e-07 0.0000 8.423750e-07 3.3000 8.820000e-07 3.3000 8.823750e-07 0.0000 1.122000e-06 0.0000 1.122375e-06 3.3000 1.162000e-06 3.3000 1.162375e-06 0.0000 1.202000e-06 0.0000 1.202375e-06 3.3000 1.242000e-06 3.3000 1.242375e-06 0.0000 1.482000e-06 0.0000 1.482375e-06 3.3000 1.602000e-06 3.3000 1.602375e-06 0.0000 1.682000e-06 0.0000 1.682375e-06 3.3000 1.722000e-06 3.3000 1.722375e-06 0.0000)
.meas tran q1 INTEG i(VDD) FROM=4.180000e-08 TO=8.180000e-08
.meas tran q2 INTEG i(VDD) FROM=8.180000e-08 TO=1.218000e-07
.meas tran q3 INTEG i(VDD) FROM=1.218000e-07 TO=1.618000e-07
.meas tran q4 INTEG i(VDD) FROM=1.618000e-07 TO=2.018000e-07
.meas tran q5 INTEG i(VDD) FROM=2.018000e-07 TO=2.418000e-07
.meas tran q6 INTEG i(VDD) FROM=2.418000e-07 TO=2.818000e-07
.meas tran q7 INTEG i(VDD) FROM=2.818000e-07 TO=3.218000e-07
.meas tran q8 INTEG i(VDD) FROM=3.218000e-07 TO=3.618000e-07
.meas tran q9 INTEG i(VDD) FROM=3.618000e-07 TO=4.018000e-07
.meas tran q10 INTEG i(VDD) FROM=4.018000e-07 TO=4.418000e-07
.meas tran q11 INTEG i(VDD) FROM=4.418000e-07 TO=4.818000e-07
.meas tran q12 INTEG i(VDD) FROM=4.818000e-07 TO=5.218000e-07
.meas tran q13 INTEG i(VDD) FROM=5.218000e-07 TO=5.618000e-07
.meas tran q14 INTEG i(VDD) FROM=5.618000e-07 TO=6.018000e-07
.meas tran q15 INTEG i(VDD) FROM=6.018000e-07 TO=6.418000e-07
.meas tran q16 INTEG i(VDD) FROM=6.418000e-07 TO=6.818000e-07
.meas tran q17 INTEG i(VDD) FROM=6.818000e-07 TO=7.218000e-07
.meas tran q18 INTEG i(VDD) FROM=7.218000e-07 TO=7.618000e-07
.meas tran q19 INTEG i(VDD) FROM=7.618000e-07 TO=8.018000e-07
.meas tran q20 INTEG i(VDD) FROM=8.018000e-07 TO=8.418000e-07
.meas tran q21 INTEG i(VDD) FROM=8.418000e-07 TO=8.818000e-07
.meas tran q22 INTEG i(VDD) FROM=8.818000e-07 TO=9.218000e-07
.meas tran q23 INTEG i(VDD) FROM=9.218000e-07 TO=9.618000e-07
.meas tran q24 INTEG i(VDD) FROM=9.618000e-07 TO=1.001800e-06
.meas tran q25 INTEG i(VDD) FROM=1.001800e-06 TO=1.041800e-06
.meas tran q26 INTEG i(VDD) FROM=1.041800e-06 TO=1.081800e-06
.meas tran q27 INTEG i(VDD) FROM=1.081800e-06 TO=1.121800e-06
.meas tran q28 INTEG i(VDD) FROM=1.121800e-06 TO=1.161800e-06
.meas tran q29 INTEG i(VDD) FROM=1.161800e-06 TO=1.201800e-06
.meas tran q30 INTEG i(VDD) FROM=1.201800e-06 TO=1.241800e-06
.meas tran q31 INTEG i(VDD) FROM=1.241800e-06 TO=1.281800e-06
.meas tran q32 INTEG i(VDD) FROM=1.281800e-06 TO=1.321800e-06
.meas tran q33 INTEG i(VDD) FROM=1.321800e-06 TO=1.361800e-06
.meas tran q34 INTEG i(VDD) FROM=1.361800e-06 TO=1.401800e-06
.meas tran q35 INTEG i(VDD) FROM=1.401800e-06 TO=1.441800e-06
.meas tran q36 INTEG i(VDD) FROM=1.441800e-06 TO=1.481800e-06
.meas tran q37 INTEG i(VDD) FROM=1.481800e-06 TO=1.521800e-06
.meas tran q38 INTEG i(VDD) FROM=1.521800e-06 TO=1.561800e-06
.meas tran q39 INTEG i(VDD) FROM=1.561800e-06 TO=1.601800e-06
.meas tran q40 INTEG i(VDD) FROM=1.601800e-06 TO=1.641800e-06
.meas tran q41 INTEG i(VDD) FROM=1.641800e-06 TO=1.681800e-06
.meas tran q42 INTEG i(VDD) FROM=1.681800e-06 TO=1.721800e-06
.meas tran q43 INTEG i(VDD) FROM=1.721800e-06 TO=1.761800e-06
.tran 20p 1.762000e-06
.end
