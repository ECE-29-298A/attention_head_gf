* NGSPICE file created from ripple_add.ext - technology: gf180mcuD

.subckt ripple_add VGND VPWR a[0] a[10] a[11] a[12] a[13] a[14] a[15] a[16] a[17]
+ a[18] a[19] a[1] a[20] a[21] a[2] a[3] a[4] a[5] a[6] a[7] a[8] a[9] b[0] b[10]
+ b[11] b[12] b[13] b[14] b[15] b[16] b[17] b[18] b[19] b[1] b[20] b[21] b[2] b[3]
+ b[4] b[5] b[6] b[7] b[8] b[9] cin s[0] s[10] s[11] s[12] s[13] s[14] s[15] s[16]
+ s[17] s[18] s[19] s[1] s[20] s[21] s[2] s[3] s[4] s[5] s[6] s[7] s[8] s[9]
X0 bitslice\[7\].u_fa/a_1072_496# b[7] VPWR VPWR pfet_05v0 ad=0.1716p pd=1.18u as=0.3456p ps=1.78u w=0.66u l=0.5u
X1 bitslice\[7\].u_fa/a_512_156# a[7] VGND VGND nfet_05v0 ad=45.6f pd=0.62u as=0.2132p ps=1.45u w=0.38u l=0.6u
X2 bitslice\[7\].u_fa/a_124_46# bitslice\[7\].u_fa/CI bitslice\[7\].u_fa/a_680_496# VPWR pfet_05v0 ad=0.2046p pd=1.28u as=0.1122p ps=1u w=0.66u l=0.5u
X3 bitslice\[7\].u_fa/a_3028_472# b[7] bitslice\[7\].u_fa/a_952_112# VPWR pfet_05v0 ad=0.119p pd=1.04u as=0.217p ps=1.32u w=0.7u l=0.5u
X4 VPWR bitslice\[7\].u_fa/CI bitslice\[7\].u_fa/a_1072_496# VPWR pfet_05v0 ad=0.2904p pd=2.2u as=0.1716p ps=1.18u w=0.66u l=0.5u
X5 bitslice\[7\].u_fa/a_1072_156# b[7] VGND VGND nfet_05v0 ad=98.8f pd=0.9u as=0.2112p ps=1.5u w=0.38u l=0.6u
X6 bitslice\[7\].u_fa/a_680_496# b[7] bitslice\[7\].u_fa/a_512_496# VPWR pfet_05v0 ad=0.1122p pd=1u as=0.1122p ps=1u w=0.66u l=0.5u
X7 bitslice\[7\].u_fa/a_1072_156# bitslice\[7\].u_fa/a_952_112# bitslice\[7\].u_fa/a_124_46# VGND nfet_05v0 ad=98.8f pd=0.9u as=98.8f ps=0.9u w=0.38u l=0.6u
X8 VGND a[7] bitslice\[7\].u_fa/a_3048_156# VGND nfet_05v0 ad=0.2363p pd=1.555u as=45.6f ps=0.62u w=0.38u l=0.6u
X9 VPWR a[7] bitslice\[7\].u_fa/a_1072_496# VPWR pfet_05v0 ad=0.3456p pd=1.78u as=0.2046p ps=1.28u w=0.66u l=0.5u
X10 bitslice\[7\].u_fa/a_952_112# bitslice\[7\].u_fa/CI bitslice\[7\].u_fa/a_1992_156# VGND nfet_05v0 ad=98.8f pd=0.9u as=0.2112p ps=1.5u w=0.38u l=0.6u
X11 VPWR bitslice\[7\].u_fa/a_124_46# s[7] VPWR pfet_05v0 ad=0.3969p pd=2.055u as=0.5346p ps=3.31u w=1.215u l=0.5u
X12 VPWR a[7] bitslice\[7\].u_fa/a_3028_472# VPWR pfet_05v0 ad=0.4073p pd=2.055u as=0.119p ps=1.04u w=0.7u l=0.5u
X13 bitslice\[7\].u_fa/a_952_112# bitslice\[7\].u_fa/CI bitslice\[7\].u_fa/a_2012_472# VPWR pfet_05v0 ad=0.217p pd=1.32u as=0.371p ps=1.76u w=0.7u l=0.5u
X14 bitslice\[8\].u_fa/CI bitslice\[7\].u_fa/a_952_112# VGND VGND nfet_05v0 ad=0.3586p pd=2.51u as=0.2363p ps=1.555u w=0.815u l=0.6u
X15 VPWR b[7] bitslice\[7\].u_fa/a_2012_472# VPWR pfet_05v0 ad=0.3792p pd=1.9u as=0.308p ps=2.28u w=0.7u l=0.5u
X16 VGND bitslice\[7\].u_fa/a_124_46# s[7] VGND nfet_05v0 ad=0.2132p pd=1.45u as=0.3124p ps=2.3u w=0.71u l=0.6u
X17 bitslice\[7\].u_fa/a_1072_496# bitslice\[7\].u_fa/a_952_112# bitslice\[7\].u_fa/a_124_46# VPWR pfet_05v0 ad=0.2046p pd=1.28u as=0.2046p ps=1.28u w=0.66u l=0.5u
X18 bitslice\[7\].u_fa/a_512_496# a[7] VPWR VPWR pfet_05v0 ad=0.1122p pd=1u as=0.3969p ps=2.055u w=0.66u l=0.5u
X19 VGND b[7] bitslice\[7\].u_fa/a_1992_156# VGND nfet_05v0 ad=0.2112p pd=1.5u as=0.1672p ps=1.64u w=0.38u l=0.6u
X20 bitslice\[7\].u_fa/a_124_46# bitslice\[7\].u_fa/CI bitslice\[7\].u_fa/a_680_156# VGND nfet_05v0 ad=98.8f pd=0.9u as=45.6f ps=0.62u w=0.38u l=0.6u
X21 bitslice\[7\].u_fa/a_680_156# b[7] bitslice\[7\].u_fa/a_512_156# VGND nfet_05v0 ad=45.6f pd=0.62u as=45.6f ps=0.62u w=0.38u l=0.6u
X22 bitslice\[8\].u_fa/CI bitslice\[7\].u_fa/a_952_112# VPWR VPWR pfet_05v0 ad=0.5346p pd=3.31u as=0.4073p ps=2.055u w=1.215u l=0.5u
X23 bitslice\[7\].u_fa/a_1992_156# a[7] VGND VGND nfet_05v0 ad=0.2112p pd=1.5u as=0.2112p ps=1.5u w=0.38u l=0.6u
X24 VGND a[7] bitslice\[7\].u_fa/a_1072_156# VGND nfet_05v0 ad=0.2112p pd=1.5u as=98.8f ps=0.9u w=0.38u l=0.6u
X25 bitslice\[7\].u_fa/a_3048_156# b[7] bitslice\[7\].u_fa/a_952_112# VGND nfet_05v0 ad=45.6f pd=0.62u as=98.8f ps=0.9u w=0.38u l=0.6u
X26 VGND bitslice\[7\].u_fa/CI bitslice\[7\].u_fa/a_1072_156# VGND nfet_05v0 ad=0.1672p pd=1.64u as=98.8f ps=0.9u w=0.38u l=0.6u
X27 bitslice\[7\].u_fa/a_2012_472# a[7] VPWR VPWR pfet_05v0 ad=0.371p pd=1.76u as=0.3792p ps=1.9u w=0.7u l=0.5u
X28 bitslice\[13\].u_fa/a_1072_496# b[13] VPWR VPWR pfet_05v0 ad=0.7524p pd=4.92u as=72.4843p ps=0.38677m w=0.66u l=0.5u
X29 bitslice\[13\].u_fa/a_512_156# a[13] VGND VGND nfet_05v0 ad=91.2f pd=1.24u as=42.3766p ps=0.30417m w=0.38u l=0.6u
X30 bitslice\[13\].u_fa/a_124_46# bitslice\[13\].u_fa/CI bitslice\[13\].u_fa/a_680_496# VPWR pfet_05v0 ad=0.4092p pd=2.56u as=0.2244p ps=2u w=0.66u l=0.5u
X31 bitslice\[13\].u_fa/a_3028_472# b[13] bitslice\[13\].u_fa/a_952_112# VPWR pfet_05v0 ad=0.238p pd=2.08u as=0.434p ps=2.64u w=0.7u l=0.5u
X32 VPWR bitslice\[13\].u_fa/CI bitslice\[13\].u_fa/a_1072_496# VPWR pfet_05v0 ad=0 pd=0 as=0 ps=0 w=0.66u l=0.5u
X33 bitslice\[13\].u_fa/a_1072_156# b[13] VGND VGND nfet_05v0 ad=0.3952p pd=3.6u as=0 ps=0 w=0.38u l=0.6u
X34 bitslice\[13\].u_fa/a_680_496# b[13] bitslice\[13\].u_fa/a_512_496# VPWR pfet_05v0 ad=0 pd=0 as=0.2244p ps=2u w=0.66u l=0.5u
X35 bitslice\[13\].u_fa/a_1072_156# bitslice\[13\].u_fa/a_952_112# bitslice\[13\].u_fa/a_124_46# VGND nfet_05v0 ad=0 pd=0 as=0.1976p ps=1.8u w=0.38u l=0.6u
X36 VGND a[13] bitslice\[13\].u_fa/a_3048_156# VGND nfet_05v0 ad=0 pd=0 as=91.2f ps=1.24u w=0.38u l=0.6u
X37 VPWR a[13] bitslice\[13\].u_fa/a_1072_496# VPWR pfet_05v0 ad=0 pd=0 as=0 ps=0 w=0.66u l=0.5u
X38 bitslice\[13\].u_fa/a_952_112# bitslice\[13\].u_fa/CI bitslice\[13\].u_fa/a_1992_156# VGND nfet_05v0 ad=0.1976p pd=1.8u as=0.5896p ps=4.64u w=0.38u l=0.6u
X39 VPWR bitslice\[13\].u_fa/a_124_46# s[13] VPWR pfet_05v0 ad=0 pd=0 as=0.5346p ps=3.31u w=1.215u l=0.5u
X40 VPWR a[13] bitslice\[13\].u_fa/a_3028_472# VPWR pfet_05v0 ad=0 pd=0 as=0 ps=0 w=0.7u l=0.5u
X41 bitslice\[13\].u_fa/a_952_112# bitslice\[13\].u_fa/CI bitslice\[13\].u_fa/a_2012_472# VPWR pfet_05v0 ad=0 pd=0 as=1.05p ps=5.8u w=0.7u l=0.5u
X42 bitslice\[14\].u_fa/CI bitslice\[13\].u_fa/a_952_112# VGND VGND nfet_05v0 ad=0.3586p pd=2.51u as=0 ps=0 w=0.815u l=0.6u
X43 VPWR b[13] bitslice\[13\].u_fa/a_2012_472# VPWR pfet_05v0 ad=0 pd=0 as=0 ps=0 w=0.7u l=0.5u
X44 VGND bitslice\[13\].u_fa/a_124_46# s[13] VGND nfet_05v0 ad=0 pd=0 as=0.3124p ps=2.3u w=0.71u l=0.6u
X45 bitslice\[13\].u_fa/a_1072_496# bitslice\[13\].u_fa/a_952_112# bitslice\[13\].u_fa/a_124_46# VPWR pfet_05v0 ad=0 pd=0 as=0 ps=0 w=0.66u l=0.5u
X46 bitslice\[13\].u_fa/a_512_496# a[13] VPWR VPWR pfet_05v0 ad=0 pd=0 as=0 ps=0 w=0.66u l=0.5u
X47 VGND b[13] bitslice\[13\].u_fa/a_1992_156# VGND nfet_05v0 ad=0 pd=0 as=0 ps=0 w=0.38u l=0.6u
X48 bitslice\[13\].u_fa/a_124_46# bitslice\[13\].u_fa/CI bitslice\[13\].u_fa/a_680_156# VGND nfet_05v0 ad=0 pd=0 as=91.2f ps=1.24u w=0.38u l=0.6u
X49 bitslice\[13\].u_fa/a_680_156# b[13] bitslice\[13\].u_fa/a_512_156# VGND nfet_05v0 ad=0 pd=0 as=0 ps=0 w=0.38u l=0.6u
X50 bitslice\[14\].u_fa/CI bitslice\[13\].u_fa/a_952_112# VPWR VPWR pfet_05v0 ad=0.5346p pd=3.31u as=0 ps=0 w=1.215u l=0.5u
X51 bitslice\[13\].u_fa/a_1992_156# a[13] VGND VGND nfet_05v0 ad=0 pd=0 as=0 ps=0 w=0.38u l=0.6u
X52 VGND a[13] bitslice\[13\].u_fa/a_1072_156# VGND nfet_05v0 ad=0 pd=0 as=0 ps=0 w=0.38u l=0.6u
X53 bitslice\[13\].u_fa/a_3048_156# b[13] bitslice\[13\].u_fa/a_952_112# VGND nfet_05v0 ad=0 pd=0 as=0 ps=0 w=0.38u l=0.6u
X54 VGND bitslice\[13\].u_fa/CI bitslice\[13\].u_fa/a_1072_156# VGND nfet_05v0 ad=0 pd=0 as=0 ps=0 w=0.38u l=0.6u
X55 bitslice\[13\].u_fa/a_2012_472# a[13] VPWR VPWR pfet_05v0 ad=0 pd=0 as=0 ps=0 w=0.7u l=0.5u
X56 bitslice\[19\].u_fa/a_1072_496# b[19] VPWR VPWR pfet_05v0 ad=0.7524p pd=4.92u as=0 ps=0 w=0.66u l=0.5u
X57 bitslice\[19\].u_fa/a_512_156# a[19] VGND VGND nfet_05v0 ad=91.2f pd=1.24u as=0 ps=0 w=0.38u l=0.6u
X58 bitslice\[19\].u_fa/a_124_46# bitslice\[19\].u_fa/CI bitslice\[19\].u_fa/a_680_496# VPWR pfet_05v0 ad=0.4092p pd=2.56u as=0.2244p ps=2u w=0.66u l=0.5u
X59 bitslice\[19\].u_fa/a_3028_472# b[19] bitslice\[19\].u_fa/a_952_112# VPWR pfet_05v0 ad=0.238p pd=2.08u as=0.434p ps=2.64u w=0.7u l=0.5u
X60 VPWR bitslice\[19\].u_fa/CI bitslice\[19\].u_fa/a_1072_496# VPWR pfet_05v0 ad=0 pd=0 as=0 ps=0 w=0.66u l=0.5u
X61 bitslice\[19\].u_fa/a_1072_156# b[19] VGND VGND nfet_05v0 ad=0.3952p pd=3.6u as=0 ps=0 w=0.38u l=0.6u
X62 bitslice\[19\].u_fa/a_680_496# b[19] bitslice\[19\].u_fa/a_512_496# VPWR pfet_05v0 ad=0 pd=0 as=0.2244p ps=2u w=0.66u l=0.5u
X63 bitslice\[19\].u_fa/a_1072_156# bitslice\[19\].u_fa/a_952_112# bitslice\[19\].u_fa/a_124_46# VGND nfet_05v0 ad=0 pd=0 as=0.1976p ps=1.8u w=0.38u l=0.6u
X64 VGND a[19] bitslice\[19\].u_fa/a_3048_156# VGND nfet_05v0 ad=0 pd=0 as=91.2f ps=1.24u w=0.38u l=0.6u
X65 VPWR a[19] bitslice\[19\].u_fa/a_1072_496# VPWR pfet_05v0 ad=0 pd=0 as=0 ps=0 w=0.66u l=0.5u
X66 bitslice\[19\].u_fa/a_952_112# bitslice\[19\].u_fa/CI bitslice\[19\].u_fa/a_1992_156# VGND nfet_05v0 ad=0.1976p pd=1.8u as=0.5896p ps=4.64u w=0.38u l=0.6u
X67 VPWR bitslice\[19\].u_fa/a_124_46# s[19] VPWR pfet_05v0 ad=0 pd=0 as=0.5346p ps=3.31u w=1.215u l=0.5u
X68 VPWR a[19] bitslice\[19\].u_fa/a_3028_472# VPWR pfet_05v0 ad=0 pd=0 as=0 ps=0 w=0.7u l=0.5u
X69 bitslice\[19\].u_fa/a_952_112# bitslice\[19\].u_fa/CI bitslice\[19\].u_fa/a_2012_472# VPWR pfet_05v0 ad=0 pd=0 as=1.05p ps=5.8u w=0.7u l=0.5u
X70 bitslice\[20\].u_fa/CI bitslice\[19\].u_fa/a_952_112# VGND VGND nfet_05v0 ad=0.3586p pd=2.51u as=0 ps=0 w=0.815u l=0.6u
X71 VPWR b[19] bitslice\[19\].u_fa/a_2012_472# VPWR pfet_05v0 ad=0 pd=0 as=0 ps=0 w=0.7u l=0.5u
X72 VGND bitslice\[19\].u_fa/a_124_46# s[19] VGND nfet_05v0 ad=0 pd=0 as=0.3124p ps=2.3u w=0.71u l=0.6u
X73 bitslice\[19\].u_fa/a_1072_496# bitslice\[19\].u_fa/a_952_112# bitslice\[19\].u_fa/a_124_46# VPWR pfet_05v0 ad=0 pd=0 as=0 ps=0 w=0.66u l=0.5u
X74 bitslice\[19\].u_fa/a_512_496# a[19] VPWR VPWR pfet_05v0 ad=0 pd=0 as=0 ps=0 w=0.66u l=0.5u
X75 VGND b[19] bitslice\[19\].u_fa/a_1992_156# VGND nfet_05v0 ad=0 pd=0 as=0 ps=0 w=0.38u l=0.6u
X76 bitslice\[19\].u_fa/a_124_46# bitslice\[19\].u_fa/CI bitslice\[19\].u_fa/a_680_156# VGND nfet_05v0 ad=0 pd=0 as=91.2f ps=1.24u w=0.38u l=0.6u
X77 bitslice\[19\].u_fa/a_680_156# b[19] bitslice\[19\].u_fa/a_512_156# VGND nfet_05v0 ad=0 pd=0 as=0 ps=0 w=0.38u l=0.6u
X78 bitslice\[20\].u_fa/CI bitslice\[19\].u_fa/a_952_112# VPWR VPWR pfet_05v0 ad=0.5346p pd=3.31u as=0 ps=0 w=1.215u l=0.5u
X79 bitslice\[19\].u_fa/a_1992_156# a[19] VGND VGND nfet_05v0 ad=0 pd=0 as=0 ps=0 w=0.38u l=0.6u
X80 VGND a[19] bitslice\[19\].u_fa/a_1072_156# VGND nfet_05v0 ad=0 pd=0 as=0 ps=0 w=0.38u l=0.6u
X81 bitslice\[19\].u_fa/a_3048_156# b[19] bitslice\[19\].u_fa/a_952_112# VGND nfet_05v0 ad=0 pd=0 as=0 ps=0 w=0.38u l=0.6u
X82 VGND bitslice\[19\].u_fa/CI bitslice\[19\].u_fa/a_1072_156# VGND nfet_05v0 ad=0 pd=0 as=0 ps=0 w=0.38u l=0.6u
X83 bitslice\[19\].u_fa/a_2012_472# a[19] VPWR VPWR pfet_05v0 ad=0 pd=0 as=0 ps=0 w=0.7u l=0.5u
X84 bitslice\[2\].u_fa/a_1072_496# b[2] VPWR VPWR pfet_05v0 ad=0.7524p pd=4.92u as=0 ps=0 w=0.66u l=0.5u
X85 bitslice\[2\].u_fa/a_512_156# a[2] VGND VGND nfet_05v0 ad=91.2f pd=1.24u as=0 ps=0 w=0.38u l=0.6u
X86 bitslice\[2\].u_fa/a_124_46# bitslice\[2\].u_fa/CI bitslice\[2\].u_fa/a_680_496# VPWR pfet_05v0 ad=0.4092p pd=2.56u as=0.2244p ps=2u w=0.66u l=0.5u
X87 bitslice\[2\].u_fa/a_3028_472# b[2] bitslice\[2\].u_fa/a_952_112# VPWR pfet_05v0 ad=0.238p pd=2.08u as=0.434p ps=2.64u w=0.7u l=0.5u
X88 VPWR bitslice\[2\].u_fa/CI bitslice\[2\].u_fa/a_1072_496# VPWR pfet_05v0 ad=0 pd=0 as=0 ps=0 w=0.66u l=0.5u
X89 bitslice\[2\].u_fa/a_1072_156# b[2] VGND VGND nfet_05v0 ad=0.3952p pd=3.6u as=0 ps=0 w=0.38u l=0.6u
X90 bitslice\[2\].u_fa/a_680_496# b[2] bitslice\[2\].u_fa/a_512_496# VPWR pfet_05v0 ad=0 pd=0 as=0.2244p ps=2u w=0.66u l=0.5u
X91 bitslice\[2\].u_fa/a_1072_156# bitslice\[2\].u_fa/a_952_112# bitslice\[2\].u_fa/a_124_46# VGND nfet_05v0 ad=0 pd=0 as=0.1976p ps=1.8u w=0.38u l=0.6u
X92 VGND a[2] bitslice\[2\].u_fa/a_3048_156# VGND nfet_05v0 ad=0 pd=0 as=91.2f ps=1.24u w=0.38u l=0.6u
X93 VPWR a[2] bitslice\[2\].u_fa/a_1072_496# VPWR pfet_05v0 ad=0 pd=0 as=0 ps=0 w=0.66u l=0.5u
X94 bitslice\[2\].u_fa/a_952_112# bitslice\[2\].u_fa/CI bitslice\[2\].u_fa/a_1992_156# VGND nfet_05v0 ad=0.1976p pd=1.8u as=0.5896p ps=4.64u w=0.38u l=0.6u
X95 VPWR bitslice\[2\].u_fa/a_124_46# s[2] VPWR pfet_05v0 ad=0 pd=0 as=0.5346p ps=3.31u w=1.215u l=0.5u
X96 VPWR a[2] bitslice\[2\].u_fa/a_3028_472# VPWR pfet_05v0 ad=0 pd=0 as=0 ps=0 w=0.7u l=0.5u
X97 bitslice\[2\].u_fa/a_952_112# bitslice\[2\].u_fa/CI bitslice\[2\].u_fa/a_2012_472# VPWR pfet_05v0 ad=0 pd=0 as=1.05p ps=5.8u w=0.7u l=0.5u
X98 bitslice\[3\].u_fa/CI bitslice\[2\].u_fa/a_952_112# VGND VGND nfet_05v0 ad=0.3586p pd=2.51u as=0 ps=0 w=0.815u l=0.6u
X99 VPWR b[2] bitslice\[2\].u_fa/a_2012_472# VPWR pfet_05v0 ad=0 pd=0 as=0 ps=0 w=0.7u l=0.5u
X100 VGND bitslice\[2\].u_fa/a_124_46# s[2] VGND nfet_05v0 ad=0 pd=0 as=0.3124p ps=2.3u w=0.71u l=0.6u
X101 bitslice\[2\].u_fa/a_1072_496# bitslice\[2\].u_fa/a_952_112# bitslice\[2\].u_fa/a_124_46# VPWR pfet_05v0 ad=0 pd=0 as=0 ps=0 w=0.66u l=0.5u
X102 bitslice\[2\].u_fa/a_512_496# a[2] VPWR VPWR pfet_05v0 ad=0 pd=0 as=0 ps=0 w=0.66u l=0.5u
X103 VGND b[2] bitslice\[2\].u_fa/a_1992_156# VGND nfet_05v0 ad=0 pd=0 as=0 ps=0 w=0.38u l=0.6u
X104 bitslice\[2\].u_fa/a_124_46# bitslice\[2\].u_fa/CI bitslice\[2\].u_fa/a_680_156# VGND nfet_05v0 ad=0 pd=0 as=91.2f ps=1.24u w=0.38u l=0.6u
X105 bitslice\[2\].u_fa/a_680_156# b[2] bitslice\[2\].u_fa/a_512_156# VGND nfet_05v0 ad=0 pd=0 as=0 ps=0 w=0.38u l=0.6u
X106 bitslice\[3\].u_fa/CI bitslice\[2\].u_fa/a_952_112# VPWR VPWR pfet_05v0 ad=0.5346p pd=3.31u as=0 ps=0 w=1.215u l=0.5u
X107 bitslice\[2\].u_fa/a_1992_156# a[2] VGND VGND nfet_05v0 ad=0 pd=0 as=0 ps=0 w=0.38u l=0.6u
X108 VGND a[2] bitslice\[2\].u_fa/a_1072_156# VGND nfet_05v0 ad=0 pd=0 as=0 ps=0 w=0.38u l=0.6u
X109 bitslice\[2\].u_fa/a_3048_156# b[2] bitslice\[2\].u_fa/a_952_112# VGND nfet_05v0 ad=0 pd=0 as=0 ps=0 w=0.38u l=0.6u
X110 VGND bitslice\[2\].u_fa/CI bitslice\[2\].u_fa/a_1072_156# VGND nfet_05v0 ad=0 pd=0 as=0 ps=0 w=0.38u l=0.6u
X111 bitslice\[2\].u_fa/a_2012_472# a[2] VPWR VPWR pfet_05v0 ad=0 pd=0 as=0 ps=0 w=0.7u l=0.5u
X112 u_msb_x3/a_952_93# b[21] u_msb_x3/a_728_93# VGND nfet_05v0 ad=57.59999f pd=0.68u as=93.59999f ps=0.88u w=0.36u l=0.6u
X113 u_msb_x3/a_728_93# b[21] u_msb_x3/a_718_524# VPWR pfet_05v0 ad=0.1469p pd=1.085u as=0.16102p ps=1.135u w=0.565u l=0.5u
X114 u_msb_x3/a_1524_472# u_msb_x3/a_728_93# u_msb_x3/a_1336_472# VPWR pfet_05v0 ad=90.4f pd=0.885u as=0.2486p ps=2.01u w=0.565u l=0.5u
X115 u_msb_x3/a_244_524# a[21] u_msb_x3/a_56_524# VPWR pfet_05v0 ad=93.59999f pd=0.88u as=0.1584p ps=1.6u w=0.36u l=0.5u
X116 u_msb_x3/a_718_524# u_msb_x3/a_56_524# VPWR VPWR pfet_05v0 ad=0.16102p pd=1.135u as=0.194p ps=1.415u w=0.565u l=0.5u
X117 u_msb_x3/a_718_524# a[21] u_msb_x3/a_728_93# VPWR pfet_05v0 ad=0.2486p pd=2.01u as=0.1469p ps=1.085u w=0.565u l=0.5u
X118 VGND b[21] u_msb_x3/a_56_524# VGND nfet_05v0 ad=0.126p pd=1.06u as=93.59999f ps=0.88u w=0.36u l=0.6u
X119 u_msb_x3/a_1336_472# u_msb_x3/a_728_93# VGND VGND nfet_05v0 ad=93.59999f pd=0.88u as=0.1584p ps=1.6u w=0.36u l=0.6u
X120 VPWR b[21] u_msb_x3/a_244_524# VPWR pfet_05v0 ad=0.194p pd=1.415u as=93.59999f ps=0.88u w=0.36u l=0.5u
X121 u_msb_x3/a_56_524# a[21] VGND VGND nfet_05v0 ad=93.59999f pd=0.88u as=0.1584p ps=1.6u w=0.36u l=0.6u
X122 VGND u_msb_x3/A3 u_msb_x3/a_1336_472# VGND nfet_05v0 ad=0.218p pd=1.52u as=93.59999f ps=0.88u w=0.36u l=0.6u
X123 u_msb_x3/a_2215_68# u_msb_x3/A3 s[21] VGND nfet_05v0 ad=0.1312p pd=1.14u as=0.2132p ps=1.34u w=0.82u l=0.6u
X124 VGND u_msb_x3/a_728_93# u_msb_x3/a_2215_68# VGND nfet_05v0 ad=0.3608p pd=2.52u as=0.1312p ps=1.14u w=0.82u l=0.6u
X125 s[21] u_msb_x3/a_1336_472# VGND VGND nfet_05v0 ad=0.2132p pd=1.34u as=0.218p ps=1.52u w=0.82u l=0.6u
X126 s[21] u_msb_x3/A3 u_msb_x3/a_1936_472# VPWR pfet_05v0 ad=0.3172p pd=1.74u as=0.3172p ps=1.74u w=1.22u l=0.5u
X127 u_msb_x3/a_728_93# u_msb_x3/a_56_524# VGND VGND nfet_05v0 ad=93.59999f pd=0.88u as=0.126p ps=1.06u w=0.36u l=0.6u
X128 u_msb_x3/a_1936_472# u_msb_x3/a_728_93# s[21] VPWR pfet_05v0 ad=0.5368p pd=3.32u as=0.3172p ps=1.74u w=1.22u l=0.5u
X129 VGND a[21] u_msb_x3/a_952_93# VGND nfet_05v0 ad=0.1584p pd=1.6u as=57.59999f ps=0.68u w=0.36u l=0.6u
X130 VPWR u_msb_x3/A3 u_msb_x3/a_1524_472# VPWR pfet_05v0 ad=0.35315p pd=1.96u as=90.4f ps=0.885u w=0.565u l=0.5u
X131 u_msb_x3/a_1936_472# u_msb_x3/a_1336_472# VPWR VPWR pfet_05v0 ad=0.3172p pd=1.74u as=0.35315p ps=1.96u w=1.22u l=0.5u
X132 bitslice\[8\].u_fa/a_1072_496# b[8] VPWR VPWR pfet_05v0 ad=0.7524p pd=4.92u as=0 ps=0 w=0.66u l=0.5u
X133 bitslice\[8\].u_fa/a_512_156# a[8] VGND VGND nfet_05v0 ad=91.2f pd=1.24u as=0 ps=0 w=0.38u l=0.6u
X134 bitslice\[8\].u_fa/a_124_46# bitslice\[8\].u_fa/CI bitslice\[8\].u_fa/a_680_496# VPWR pfet_05v0 ad=0.4092p pd=2.56u as=0.2244p ps=2u w=0.66u l=0.5u
X135 bitslice\[8\].u_fa/a_3028_472# b[8] bitslice\[8\].u_fa/a_952_112# VPWR pfet_05v0 ad=0.238p pd=2.08u as=0.434p ps=2.64u w=0.7u l=0.5u
X136 VPWR bitslice\[8\].u_fa/CI bitslice\[8\].u_fa/a_1072_496# VPWR pfet_05v0 ad=0 pd=0 as=0 ps=0 w=0.66u l=0.5u
X137 bitslice\[8\].u_fa/a_1072_156# b[8] VGND VGND nfet_05v0 ad=0.3952p pd=3.6u as=0 ps=0 w=0.38u l=0.6u
X138 bitslice\[8\].u_fa/a_680_496# b[8] bitslice\[8\].u_fa/a_512_496# VPWR pfet_05v0 ad=0 pd=0 as=0.2244p ps=2u w=0.66u l=0.5u
X139 bitslice\[8\].u_fa/a_1072_156# bitslice\[8\].u_fa/a_952_112# bitslice\[8\].u_fa/a_124_46# VGND nfet_05v0 ad=0 pd=0 as=0.1976p ps=1.8u w=0.38u l=0.6u
X140 VGND a[8] bitslice\[8\].u_fa/a_3048_156# VGND nfet_05v0 ad=0 pd=0 as=91.2f ps=1.24u w=0.38u l=0.6u
X141 VPWR a[8] bitslice\[8\].u_fa/a_1072_496# VPWR pfet_05v0 ad=0 pd=0 as=0 ps=0 w=0.66u l=0.5u
X142 bitslice\[8\].u_fa/a_952_112# bitslice\[8\].u_fa/CI bitslice\[8\].u_fa/a_1992_156# VGND nfet_05v0 ad=0.1976p pd=1.8u as=0.5896p ps=4.64u w=0.38u l=0.6u
X143 VPWR bitslice\[8\].u_fa/a_124_46# s[8] VPWR pfet_05v0 ad=0 pd=0 as=0.5346p ps=3.31u w=1.215u l=0.5u
X144 VPWR a[8] bitslice\[8\].u_fa/a_3028_472# VPWR pfet_05v0 ad=0 pd=0 as=0 ps=0 w=0.7u l=0.5u
X145 bitslice\[8\].u_fa/a_952_112# bitslice\[8\].u_fa/CI bitslice\[8\].u_fa/a_2012_472# VPWR pfet_05v0 ad=0 pd=0 as=1.05p ps=5.8u w=0.7u l=0.5u
X146 bitslice\[9\].u_fa/CI bitslice\[8\].u_fa/a_952_112# VGND VGND nfet_05v0 ad=0.3586p pd=2.51u as=0 ps=0 w=0.815u l=0.6u
X147 VPWR b[8] bitslice\[8\].u_fa/a_2012_472# VPWR pfet_05v0 ad=0 pd=0 as=0 ps=0 w=0.7u l=0.5u
X148 VGND bitslice\[8\].u_fa/a_124_46# s[8] VGND nfet_05v0 ad=0 pd=0 as=0.3124p ps=2.3u w=0.71u l=0.6u
X149 bitslice\[8\].u_fa/a_1072_496# bitslice\[8\].u_fa/a_952_112# bitslice\[8\].u_fa/a_124_46# VPWR pfet_05v0 ad=0 pd=0 as=0 ps=0 w=0.66u l=0.5u
X150 bitslice\[8\].u_fa/a_512_496# a[8] VPWR VPWR pfet_05v0 ad=0 pd=0 as=0 ps=0 w=0.66u l=0.5u
X151 VGND b[8] bitslice\[8\].u_fa/a_1992_156# VGND nfet_05v0 ad=0 pd=0 as=0 ps=0 w=0.38u l=0.6u
X152 bitslice\[8\].u_fa/a_124_46# bitslice\[8\].u_fa/CI bitslice\[8\].u_fa/a_680_156# VGND nfet_05v0 ad=0 pd=0 as=91.2f ps=1.24u w=0.38u l=0.6u
X153 bitslice\[8\].u_fa/a_680_156# b[8] bitslice\[8\].u_fa/a_512_156# VGND nfet_05v0 ad=0 pd=0 as=0 ps=0 w=0.38u l=0.6u
X154 bitslice\[9\].u_fa/CI bitslice\[8\].u_fa/a_952_112# VPWR VPWR pfet_05v0 ad=0.5346p pd=3.31u as=0 ps=0 w=1.215u l=0.5u
X155 bitslice\[8\].u_fa/a_1992_156# a[8] VGND VGND nfet_05v0 ad=0 pd=0 as=0 ps=0 w=0.38u l=0.6u
X156 VGND a[8] bitslice\[8\].u_fa/a_1072_156# VGND nfet_05v0 ad=0 pd=0 as=0 ps=0 w=0.38u l=0.6u
X157 bitslice\[8\].u_fa/a_3048_156# b[8] bitslice\[8\].u_fa/a_952_112# VGND nfet_05v0 ad=0 pd=0 as=0 ps=0 w=0.38u l=0.6u
X158 VGND bitslice\[8\].u_fa/CI bitslice\[8\].u_fa/a_1072_156# VGND nfet_05v0 ad=0 pd=0 as=0 ps=0 w=0.38u l=0.6u
X159 bitslice\[8\].u_fa/a_2012_472# a[8] VPWR VPWR pfet_05v0 ad=0 pd=0 as=0 ps=0 w=0.7u l=0.5u
X160 bitslice\[14\].u_fa/a_1072_496# b[14] VPWR VPWR pfet_05v0 ad=0.7524p pd=4.92u as=0 ps=0 w=0.66u l=0.5u
X161 bitslice\[14\].u_fa/a_512_156# a[14] VGND VGND nfet_05v0 ad=91.2f pd=1.24u as=0 ps=0 w=0.38u l=0.6u
X162 bitslice\[14\].u_fa/a_124_46# bitslice\[14\].u_fa/CI bitslice\[14\].u_fa/a_680_496# VPWR pfet_05v0 ad=0.4092p pd=2.56u as=0.2244p ps=2u w=0.66u l=0.5u
X163 bitslice\[14\].u_fa/a_3028_472# b[14] bitslice\[14\].u_fa/a_952_112# VPWR pfet_05v0 ad=0.238p pd=2.08u as=0.434p ps=2.64u w=0.7u l=0.5u
X164 VPWR bitslice\[14\].u_fa/CI bitslice\[14\].u_fa/a_1072_496# VPWR pfet_05v0 ad=0 pd=0 as=0 ps=0 w=0.66u l=0.5u
X165 bitslice\[14\].u_fa/a_1072_156# b[14] VGND VGND nfet_05v0 ad=0.3952p pd=3.6u as=0 ps=0 w=0.38u l=0.6u
X166 bitslice\[14\].u_fa/a_680_496# b[14] bitslice\[14\].u_fa/a_512_496# VPWR pfet_05v0 ad=0 pd=0 as=0.2244p ps=2u w=0.66u l=0.5u
X167 bitslice\[14\].u_fa/a_1072_156# bitslice\[14\].u_fa/a_952_112# bitslice\[14\].u_fa/a_124_46# VGND nfet_05v0 ad=0 pd=0 as=0.1976p ps=1.8u w=0.38u l=0.6u
X168 VGND a[14] bitslice\[14\].u_fa/a_3048_156# VGND nfet_05v0 ad=0 pd=0 as=91.2f ps=1.24u w=0.38u l=0.6u
X169 VPWR a[14] bitslice\[14\].u_fa/a_1072_496# VPWR pfet_05v0 ad=0 pd=0 as=0 ps=0 w=0.66u l=0.5u
X170 bitslice\[14\].u_fa/a_952_112# bitslice\[14\].u_fa/CI bitslice\[14\].u_fa/a_1992_156# VGND nfet_05v0 ad=0.1976p pd=1.8u as=0.5896p ps=4.64u w=0.38u l=0.6u
X171 VPWR bitslice\[14\].u_fa/a_124_46# s[14] VPWR pfet_05v0 ad=0 pd=0 as=0.5346p ps=3.31u w=1.215u l=0.5u
X172 VPWR a[14] bitslice\[14\].u_fa/a_3028_472# VPWR pfet_05v0 ad=0 pd=0 as=0 ps=0 w=0.7u l=0.5u
X173 bitslice\[14\].u_fa/a_952_112# bitslice\[14\].u_fa/CI bitslice\[14\].u_fa/a_2012_472# VPWR pfet_05v0 ad=0 pd=0 as=1.05p ps=5.8u w=0.7u l=0.5u
X174 bitslice\[15\].u_fa/CI bitslice\[14\].u_fa/a_952_112# VGND VGND nfet_05v0 ad=0.3586p pd=2.51u as=0 ps=0 w=0.815u l=0.6u
X175 VPWR b[14] bitslice\[14\].u_fa/a_2012_472# VPWR pfet_05v0 ad=0 pd=0 as=0 ps=0 w=0.7u l=0.5u
X176 VGND bitslice\[14\].u_fa/a_124_46# s[14] VGND nfet_05v0 ad=0 pd=0 as=0.3124p ps=2.3u w=0.71u l=0.6u
X177 bitslice\[14\].u_fa/a_1072_496# bitslice\[14\].u_fa/a_952_112# bitslice\[14\].u_fa/a_124_46# VPWR pfet_05v0 ad=0 pd=0 as=0 ps=0 w=0.66u l=0.5u
X178 bitslice\[14\].u_fa/a_512_496# a[14] VPWR VPWR pfet_05v0 ad=0 pd=0 as=0 ps=0 w=0.66u l=0.5u
X179 VGND b[14] bitslice\[14\].u_fa/a_1992_156# VGND nfet_05v0 ad=0 pd=0 as=0 ps=0 w=0.38u l=0.6u
X180 bitslice\[14\].u_fa/a_124_46# bitslice\[14\].u_fa/CI bitslice\[14\].u_fa/a_680_156# VGND nfet_05v0 ad=0 pd=0 as=91.2f ps=1.24u w=0.38u l=0.6u
X181 bitslice\[14\].u_fa/a_680_156# b[14] bitslice\[14\].u_fa/a_512_156# VGND nfet_05v0 ad=0 pd=0 as=0 ps=0 w=0.38u l=0.6u
X182 bitslice\[15\].u_fa/CI bitslice\[14\].u_fa/a_952_112# VPWR VPWR pfet_05v0 ad=0.5346p pd=3.31u as=0 ps=0 w=1.215u l=0.5u
X183 bitslice\[14\].u_fa/a_1992_156# a[14] VGND VGND nfet_05v0 ad=0 pd=0 as=0 ps=0 w=0.38u l=0.6u
X184 VGND a[14] bitslice\[14\].u_fa/a_1072_156# VGND nfet_05v0 ad=0 pd=0 as=0 ps=0 w=0.38u l=0.6u
X185 bitslice\[14\].u_fa/a_3048_156# b[14] bitslice\[14\].u_fa/a_952_112# VGND nfet_05v0 ad=0 pd=0 as=0 ps=0 w=0.38u l=0.6u
X186 VGND bitslice\[14\].u_fa/CI bitslice\[14\].u_fa/a_1072_156# VGND nfet_05v0 ad=0 pd=0 as=0 ps=0 w=0.38u l=0.6u
X187 bitslice\[14\].u_fa/a_2012_472# a[14] VPWR VPWR pfet_05v0 ad=0 pd=0 as=0 ps=0 w=0.7u l=0.5u
X188 bitslice\[20\].u_fa/a_1072_496# b[20] VPWR VPWR pfet_05v0 ad=0.7524p pd=4.92u as=0 ps=0 w=0.66u l=0.5u
X189 bitslice\[20\].u_fa/a_512_156# a[20] VGND VGND nfet_05v0 ad=91.2f pd=1.24u as=0 ps=0 w=0.38u l=0.6u
X190 bitslice\[20\].u_fa/a_124_46# bitslice\[20\].u_fa/CI bitslice\[20\].u_fa/a_680_496# VPWR pfet_05v0 ad=0.4092p pd=2.56u as=0.2244p ps=2u w=0.66u l=0.5u
X191 bitslice\[20\].u_fa/a_3028_472# b[20] bitslice\[20\].u_fa/a_952_112# VPWR pfet_05v0 ad=0.238p pd=2.08u as=0.434p ps=2.64u w=0.7u l=0.5u
X192 VPWR bitslice\[20\].u_fa/CI bitslice\[20\].u_fa/a_1072_496# VPWR pfet_05v0 ad=0 pd=0 as=0 ps=0 w=0.66u l=0.5u
X193 bitslice\[20\].u_fa/a_1072_156# b[20] VGND VGND nfet_05v0 ad=0.3952p pd=3.6u as=0 ps=0 w=0.38u l=0.6u
X194 bitslice\[20\].u_fa/a_680_496# b[20] bitslice\[20\].u_fa/a_512_496# VPWR pfet_05v0 ad=0 pd=0 as=0.2244p ps=2u w=0.66u l=0.5u
X195 bitslice\[20\].u_fa/a_1072_156# bitslice\[20\].u_fa/a_952_112# bitslice\[20\].u_fa/a_124_46# VGND nfet_05v0 ad=0 pd=0 as=0.1976p ps=1.8u w=0.38u l=0.6u
X196 VGND a[20] bitslice\[20\].u_fa/a_3048_156# VGND nfet_05v0 ad=0 pd=0 as=91.2f ps=1.24u w=0.38u l=0.6u
X197 VPWR a[20] bitslice\[20\].u_fa/a_1072_496# VPWR pfet_05v0 ad=0 pd=0 as=0 ps=0 w=0.66u l=0.5u
X198 bitslice\[20\].u_fa/a_952_112# bitslice\[20\].u_fa/CI bitslice\[20\].u_fa/a_1992_156# VGND nfet_05v0 ad=0.1976p pd=1.8u as=0.5896p ps=4.64u w=0.38u l=0.6u
X199 VPWR bitslice\[20\].u_fa/a_124_46# s[20] VPWR pfet_05v0 ad=0 pd=0 as=0.5346p ps=3.31u w=1.215u l=0.5u
X200 VPWR a[20] bitslice\[20\].u_fa/a_3028_472# VPWR pfet_05v0 ad=0 pd=0 as=0 ps=0 w=0.7u l=0.5u
X201 bitslice\[20\].u_fa/a_952_112# bitslice\[20\].u_fa/CI bitslice\[20\].u_fa/a_2012_472# VPWR pfet_05v0 ad=0 pd=0 as=1.05p ps=5.8u w=0.7u l=0.5u
X202 u_msb_x3/A3 bitslice\[20\].u_fa/a_952_112# VGND VGND nfet_05v0 ad=0.3586p pd=2.51u as=0 ps=0 w=0.815u l=0.6u
X203 VPWR b[20] bitslice\[20\].u_fa/a_2012_472# VPWR pfet_05v0 ad=0 pd=0 as=0 ps=0 w=0.7u l=0.5u
X204 VGND bitslice\[20\].u_fa/a_124_46# s[20] VGND nfet_05v0 ad=0 pd=0 as=0.3124p ps=2.3u w=0.71u l=0.6u
X205 bitslice\[20\].u_fa/a_1072_496# bitslice\[20\].u_fa/a_952_112# bitslice\[20\].u_fa/a_124_46# VPWR pfet_05v0 ad=0 pd=0 as=0 ps=0 w=0.66u l=0.5u
X206 bitslice\[20\].u_fa/a_512_496# a[20] VPWR VPWR pfet_05v0 ad=0 pd=0 as=0 ps=0 w=0.66u l=0.5u
X207 VGND b[20] bitslice\[20\].u_fa/a_1992_156# VGND nfet_05v0 ad=0 pd=0 as=0 ps=0 w=0.38u l=0.6u
X208 bitslice\[20\].u_fa/a_124_46# bitslice\[20\].u_fa/CI bitslice\[20\].u_fa/a_680_156# VGND nfet_05v0 ad=0 pd=0 as=91.2f ps=1.24u w=0.38u l=0.6u
X209 bitslice\[20\].u_fa/a_680_156# b[20] bitslice\[20\].u_fa/a_512_156# VGND nfet_05v0 ad=0 pd=0 as=0 ps=0 w=0.38u l=0.6u
X210 u_msb_x3/A3 bitslice\[20\].u_fa/a_952_112# VPWR VPWR pfet_05v0 ad=0.5346p pd=3.31u as=0 ps=0 w=1.215u l=0.5u
X211 bitslice\[20\].u_fa/a_1992_156# a[20] VGND VGND nfet_05v0 ad=0 pd=0 as=0 ps=0 w=0.38u l=0.6u
X212 VGND a[20] bitslice\[20\].u_fa/a_1072_156# VGND nfet_05v0 ad=0 pd=0 as=0 ps=0 w=0.38u l=0.6u
X213 bitslice\[20\].u_fa/a_3048_156# b[20] bitslice\[20\].u_fa/a_952_112# VGND nfet_05v0 ad=0 pd=0 as=0 ps=0 w=0.38u l=0.6u
X214 VGND bitslice\[20\].u_fa/CI bitslice\[20\].u_fa/a_1072_156# VGND nfet_05v0 ad=0 pd=0 as=0 ps=0 w=0.38u l=0.6u
X215 bitslice\[20\].u_fa/a_2012_472# a[20] VPWR VPWR pfet_05v0 ad=0 pd=0 as=0 ps=0 w=0.7u l=0.5u
X216 bitslice\[3\].u_fa/a_1072_496# b[3] VPWR VPWR pfet_05v0 ad=0.7524p pd=4.92u as=0 ps=0 w=0.66u l=0.5u
X217 bitslice\[3\].u_fa/a_512_156# a[3] VGND VGND nfet_05v0 ad=91.2f pd=1.24u as=0 ps=0 w=0.38u l=0.6u
X218 bitslice\[3\].u_fa/a_124_46# bitslice\[3\].u_fa/CI bitslice\[3\].u_fa/a_680_496# VPWR pfet_05v0 ad=0.4092p pd=2.56u as=0.2244p ps=2u w=0.66u l=0.5u
X219 bitslice\[3\].u_fa/a_3028_472# b[3] bitslice\[3\].u_fa/a_952_112# VPWR pfet_05v0 ad=0.238p pd=2.08u as=0.434p ps=2.64u w=0.7u l=0.5u
X220 VPWR bitslice\[3\].u_fa/CI bitslice\[3\].u_fa/a_1072_496# VPWR pfet_05v0 ad=0 pd=0 as=0 ps=0 w=0.66u l=0.5u
X221 bitslice\[3\].u_fa/a_1072_156# b[3] VGND VGND nfet_05v0 ad=0.3952p pd=3.6u as=0 ps=0 w=0.38u l=0.6u
X222 bitslice\[3\].u_fa/a_680_496# b[3] bitslice\[3\].u_fa/a_512_496# VPWR pfet_05v0 ad=0 pd=0 as=0.2244p ps=2u w=0.66u l=0.5u
X223 bitslice\[3\].u_fa/a_1072_156# bitslice\[3\].u_fa/a_952_112# bitslice\[3\].u_fa/a_124_46# VGND nfet_05v0 ad=0 pd=0 as=0.1976p ps=1.8u w=0.38u l=0.6u
X224 VGND a[3] bitslice\[3\].u_fa/a_3048_156# VGND nfet_05v0 ad=0 pd=0 as=91.2f ps=1.24u w=0.38u l=0.6u
X225 VPWR a[3] bitslice\[3\].u_fa/a_1072_496# VPWR pfet_05v0 ad=0 pd=0 as=0 ps=0 w=0.66u l=0.5u
X226 bitslice\[3\].u_fa/a_952_112# bitslice\[3\].u_fa/CI bitslice\[3\].u_fa/a_1992_156# VGND nfet_05v0 ad=0.1976p pd=1.8u as=0.5896p ps=4.64u w=0.38u l=0.6u
X227 VPWR bitslice\[3\].u_fa/a_124_46# s[3] VPWR pfet_05v0 ad=0 pd=0 as=0.5346p ps=3.31u w=1.215u l=0.5u
X228 VPWR a[3] bitslice\[3\].u_fa/a_3028_472# VPWR pfet_05v0 ad=0 pd=0 as=0 ps=0 w=0.7u l=0.5u
X229 bitslice\[3\].u_fa/a_952_112# bitslice\[3\].u_fa/CI bitslice\[3\].u_fa/a_2012_472# VPWR pfet_05v0 ad=0 pd=0 as=1.05p ps=5.8u w=0.7u l=0.5u
X230 bitslice\[4\].u_fa/CI bitslice\[3\].u_fa/a_952_112# VGND VGND nfet_05v0 ad=0.3586p pd=2.51u as=0 ps=0 w=0.815u l=0.6u
X231 VPWR b[3] bitslice\[3\].u_fa/a_2012_472# VPWR pfet_05v0 ad=0 pd=0 as=0 ps=0 w=0.7u l=0.5u
X232 VGND bitslice\[3\].u_fa/a_124_46# s[3] VGND nfet_05v0 ad=0 pd=0 as=0.3124p ps=2.3u w=0.71u l=0.6u
X233 bitslice\[3\].u_fa/a_1072_496# bitslice\[3\].u_fa/a_952_112# bitslice\[3\].u_fa/a_124_46# VPWR pfet_05v0 ad=0 pd=0 as=0 ps=0 w=0.66u l=0.5u
X234 bitslice\[3\].u_fa/a_512_496# a[3] VPWR VPWR pfet_05v0 ad=0 pd=0 as=0 ps=0 w=0.66u l=0.5u
X235 VGND b[3] bitslice\[3\].u_fa/a_1992_156# VGND nfet_05v0 ad=0 pd=0 as=0 ps=0 w=0.38u l=0.6u
X236 bitslice\[3\].u_fa/a_124_46# bitslice\[3\].u_fa/CI bitslice\[3\].u_fa/a_680_156# VGND nfet_05v0 ad=0 pd=0 as=91.2f ps=1.24u w=0.38u l=0.6u
X237 bitslice\[3\].u_fa/a_680_156# b[3] bitslice\[3\].u_fa/a_512_156# VGND nfet_05v0 ad=0 pd=0 as=0 ps=0 w=0.38u l=0.6u
X238 bitslice\[4\].u_fa/CI bitslice\[3\].u_fa/a_952_112# VPWR VPWR pfet_05v0 ad=0.5346p pd=3.31u as=0 ps=0 w=1.215u l=0.5u
X239 bitslice\[3\].u_fa/a_1992_156# a[3] VGND VGND nfet_05v0 ad=0 pd=0 as=0 ps=0 w=0.38u l=0.6u
X240 VGND a[3] bitslice\[3\].u_fa/a_1072_156# VGND nfet_05v0 ad=0 pd=0 as=0 ps=0 w=0.38u l=0.6u
X241 bitslice\[3\].u_fa/a_3048_156# b[3] bitslice\[3\].u_fa/a_952_112# VGND nfet_05v0 ad=0 pd=0 as=0 ps=0 w=0.38u l=0.6u
X242 VGND bitslice\[3\].u_fa/CI bitslice\[3\].u_fa/a_1072_156# VGND nfet_05v0 ad=0 pd=0 as=0 ps=0 w=0.38u l=0.6u
X243 bitslice\[3\].u_fa/a_2012_472# a[3] VPWR VPWR pfet_05v0 ad=0 pd=0 as=0 ps=0 w=0.7u l=0.5u
X244 VPWR FILLER_21_2/a_572_375# FILLER_21_2/a_484_472# VPWR pfet_05v0 ad=0.5368p pd=3.32u as=0.5368p ps=3.32u w=1.22u l=1u
X245 FILLER_21_2/a_572_375# FILLER_21_2/a_484_472# VGND VGND nfet_05v0 ad=0.3608p pd=2.52u as=0.3608p ps=2.52u w=0.82u l=1u
X246 FILLER_21_2/a_124_375# FILLER_21_2/a_36_472# VGND VGND nfet_05v0 ad=0.3608p pd=2.52u as=0.3608p ps=2.52u w=0.82u l=1u
X247 VPWR FILLER_21_2/a_124_375# FILLER_21_2/a_36_472# VPWR pfet_05v0 ad=0.5368p pd=3.32u as=0.5368p ps=3.32u w=1.22u l=1u
X248 bitslice\[9\].u_fa/a_1072_496# b[9] VPWR VPWR pfet_05v0 ad=0.7524p pd=4.92u as=0 ps=0 w=0.66u l=0.5u
X249 bitslice\[9\].u_fa/a_512_156# a[9] VGND VGND nfet_05v0 ad=91.2f pd=1.24u as=0 ps=0 w=0.38u l=0.6u
X250 bitslice\[9\].u_fa/a_124_46# bitslice\[9\].u_fa/CI bitslice\[9\].u_fa/a_680_496# VPWR pfet_05v0 ad=0.4092p pd=2.56u as=0.2244p ps=2u w=0.66u l=0.5u
X251 bitslice\[9\].u_fa/a_3028_472# b[9] bitslice\[9\].u_fa/a_952_112# VPWR pfet_05v0 ad=0.238p pd=2.08u as=0.434p ps=2.64u w=0.7u l=0.5u
X252 VPWR bitslice\[9\].u_fa/CI bitslice\[9\].u_fa/a_1072_496# VPWR pfet_05v0 ad=0 pd=0 as=0 ps=0 w=0.66u l=0.5u
X253 bitslice\[9\].u_fa/a_1072_156# b[9] VGND VGND nfet_05v0 ad=0.3952p pd=3.6u as=0 ps=0 w=0.38u l=0.6u
X254 bitslice\[9\].u_fa/a_680_496# b[9] bitslice\[9\].u_fa/a_512_496# VPWR pfet_05v0 ad=0 pd=0 as=0.2244p ps=2u w=0.66u l=0.5u
X255 bitslice\[9\].u_fa/a_1072_156# bitslice\[9\].u_fa/a_952_112# bitslice\[9\].u_fa/a_124_46# VGND nfet_05v0 ad=0 pd=0 as=0.1976p ps=1.8u w=0.38u l=0.6u
X256 VGND a[9] bitslice\[9\].u_fa/a_3048_156# VGND nfet_05v0 ad=0 pd=0 as=91.2f ps=1.24u w=0.38u l=0.6u
X257 VPWR a[9] bitslice\[9\].u_fa/a_1072_496# VPWR pfet_05v0 ad=0 pd=0 as=0 ps=0 w=0.66u l=0.5u
X258 bitslice\[9\].u_fa/a_952_112# bitslice\[9\].u_fa/CI bitslice\[9\].u_fa/a_1992_156# VGND nfet_05v0 ad=0.1976p pd=1.8u as=0.5896p ps=4.64u w=0.38u l=0.6u
X259 VPWR bitslice\[9\].u_fa/a_124_46# s[9] VPWR pfet_05v0 ad=0 pd=0 as=0.5346p ps=3.31u w=1.215u l=0.5u
X260 VPWR a[9] bitslice\[9\].u_fa/a_3028_472# VPWR pfet_05v0 ad=0 pd=0 as=0 ps=0 w=0.7u l=0.5u
X261 bitslice\[9\].u_fa/a_952_112# bitslice\[9\].u_fa/CI bitslice\[9\].u_fa/a_2012_472# VPWR pfet_05v0 ad=0 pd=0 as=1.05p ps=5.8u w=0.7u l=0.5u
X262 bitslice\[9\].u_fa/CO bitslice\[9\].u_fa/a_952_112# VGND VGND nfet_05v0 ad=0.3586p pd=2.51u as=0 ps=0 w=0.815u l=0.6u
X263 VPWR b[9] bitslice\[9\].u_fa/a_2012_472# VPWR pfet_05v0 ad=0 pd=0 as=0 ps=0 w=0.7u l=0.5u
X264 VGND bitslice\[9\].u_fa/a_124_46# s[9] VGND nfet_05v0 ad=0 pd=0 as=0.3124p ps=2.3u w=0.71u l=0.6u
X265 bitslice\[9\].u_fa/a_1072_496# bitslice\[9\].u_fa/a_952_112# bitslice\[9\].u_fa/a_124_46# VPWR pfet_05v0 ad=0 pd=0 as=0 ps=0 w=0.66u l=0.5u
X266 bitslice\[9\].u_fa/a_512_496# a[9] VPWR VPWR pfet_05v0 ad=0 pd=0 as=0 ps=0 w=0.66u l=0.5u
X267 VGND b[9] bitslice\[9\].u_fa/a_1992_156# VGND nfet_05v0 ad=0 pd=0 as=0 ps=0 w=0.38u l=0.6u
X268 bitslice\[9\].u_fa/a_124_46# bitslice\[9\].u_fa/CI bitslice\[9\].u_fa/a_680_156# VGND nfet_05v0 ad=0 pd=0 as=91.2f ps=1.24u w=0.38u l=0.6u
X269 bitslice\[9\].u_fa/a_680_156# b[9] bitslice\[9\].u_fa/a_512_156# VGND nfet_05v0 ad=0 pd=0 as=0 ps=0 w=0.38u l=0.6u
X270 bitslice\[9\].u_fa/CO bitslice\[9\].u_fa/a_952_112# VPWR VPWR pfet_05v0 ad=0.5346p pd=3.31u as=0 ps=0 w=1.215u l=0.5u
X271 bitslice\[9\].u_fa/a_1992_156# a[9] VGND VGND nfet_05v0 ad=0 pd=0 as=0 ps=0 w=0.38u l=0.6u
X272 VGND a[9] bitslice\[9\].u_fa/a_1072_156# VGND nfet_05v0 ad=0 pd=0 as=0 ps=0 w=0.38u l=0.6u
X273 bitslice\[9\].u_fa/a_3048_156# b[9] bitslice\[9\].u_fa/a_952_112# VGND nfet_05v0 ad=0 pd=0 as=0 ps=0 w=0.38u l=0.6u
X274 VGND bitslice\[9\].u_fa/CI bitslice\[9\].u_fa/a_1072_156# VGND nfet_05v0 ad=0 pd=0 as=0 ps=0 w=0.38u l=0.6u
X275 bitslice\[9\].u_fa/a_2012_472# a[9] VPWR VPWR pfet_05v0 ad=0 pd=0 as=0 ps=0 w=0.7u l=0.5u
X276 bitslice\[15\].u_fa/a_1072_496# b[15] VPWR VPWR pfet_05v0 ad=0.7524p pd=4.92u as=0 ps=0 w=0.66u l=0.5u
X277 bitslice\[15\].u_fa/a_512_156# a[15] VGND VGND nfet_05v0 ad=91.2f pd=1.24u as=0 ps=0 w=0.38u l=0.6u
X278 bitslice\[15\].u_fa/a_124_46# bitslice\[15\].u_fa/CI bitslice\[15\].u_fa/a_680_496# VPWR pfet_05v0 ad=0.4092p pd=2.56u as=0.2244p ps=2u w=0.66u l=0.5u
X279 bitslice\[15\].u_fa/a_3028_472# b[15] bitslice\[15\].u_fa/a_952_112# VPWR pfet_05v0 ad=0.238p pd=2.08u as=0.434p ps=2.64u w=0.7u l=0.5u
X280 VPWR bitslice\[15\].u_fa/CI bitslice\[15\].u_fa/a_1072_496# VPWR pfet_05v0 ad=0 pd=0 as=0 ps=0 w=0.66u l=0.5u
X281 bitslice\[15\].u_fa/a_1072_156# b[15] VGND VGND nfet_05v0 ad=0.3952p pd=3.6u as=0 ps=0 w=0.38u l=0.6u
X282 bitslice\[15\].u_fa/a_680_496# b[15] bitslice\[15\].u_fa/a_512_496# VPWR pfet_05v0 ad=0 pd=0 as=0.2244p ps=2u w=0.66u l=0.5u
X283 bitslice\[15\].u_fa/a_1072_156# bitslice\[15\].u_fa/a_952_112# bitslice\[15\].u_fa/a_124_46# VGND nfet_05v0 ad=0 pd=0 as=0.1976p ps=1.8u w=0.38u l=0.6u
X284 VGND a[15] bitslice\[15\].u_fa/a_3048_156# VGND nfet_05v0 ad=0 pd=0 as=91.2f ps=1.24u w=0.38u l=0.6u
X285 VPWR a[15] bitslice\[15\].u_fa/a_1072_496# VPWR pfet_05v0 ad=0 pd=0 as=0 ps=0 w=0.66u l=0.5u
X286 bitslice\[15\].u_fa/a_952_112# bitslice\[15\].u_fa/CI bitslice\[15\].u_fa/a_1992_156# VGND nfet_05v0 ad=0.1976p pd=1.8u as=0.5896p ps=4.64u w=0.38u l=0.6u
X287 VPWR bitslice\[15\].u_fa/a_124_46# s[15] VPWR pfet_05v0 ad=0 pd=0 as=0.5346p ps=3.31u w=1.215u l=0.5u
X288 VPWR a[15] bitslice\[15\].u_fa/a_3028_472# VPWR pfet_05v0 ad=0 pd=0 as=0 ps=0 w=0.7u l=0.5u
X289 bitslice\[15\].u_fa/a_952_112# bitslice\[15\].u_fa/CI bitslice\[15\].u_fa/a_2012_472# VPWR pfet_05v0 ad=0 pd=0 as=1.05p ps=5.8u w=0.7u l=0.5u
X290 bitslice\[16\].u_fa/CI bitslice\[15\].u_fa/a_952_112# VGND VGND nfet_05v0 ad=0.3586p pd=2.51u as=0 ps=0 w=0.815u l=0.6u
X291 VPWR b[15] bitslice\[15\].u_fa/a_2012_472# VPWR pfet_05v0 ad=0 pd=0 as=0 ps=0 w=0.7u l=0.5u
X292 VGND bitslice\[15\].u_fa/a_124_46# s[15] VGND nfet_05v0 ad=0 pd=0 as=0.3124p ps=2.3u w=0.71u l=0.6u
X293 bitslice\[15\].u_fa/a_1072_496# bitslice\[15\].u_fa/a_952_112# bitslice\[15\].u_fa/a_124_46# VPWR pfet_05v0 ad=0 pd=0 as=0 ps=0 w=0.66u l=0.5u
X294 bitslice\[15\].u_fa/a_512_496# a[15] VPWR VPWR pfet_05v0 ad=0 pd=0 as=0 ps=0 w=0.66u l=0.5u
X295 VGND b[15] bitslice\[15\].u_fa/a_1992_156# VGND nfet_05v0 ad=0 pd=0 as=0 ps=0 w=0.38u l=0.6u
X296 bitslice\[15\].u_fa/a_124_46# bitslice\[15\].u_fa/CI bitslice\[15\].u_fa/a_680_156# VGND nfet_05v0 ad=0 pd=0 as=91.2f ps=1.24u w=0.38u l=0.6u
X297 bitslice\[15\].u_fa/a_680_156# b[15] bitslice\[15\].u_fa/a_512_156# VGND nfet_05v0 ad=0 pd=0 as=0 ps=0 w=0.38u l=0.6u
X298 bitslice\[16\].u_fa/CI bitslice\[15\].u_fa/a_952_112# VPWR VPWR pfet_05v0 ad=0.5346p pd=3.31u as=0 ps=0 w=1.215u l=0.5u
X299 bitslice\[15\].u_fa/a_1992_156# a[15] VGND VGND nfet_05v0 ad=0 pd=0 as=0 ps=0 w=0.38u l=0.6u
X300 VGND a[15] bitslice\[15\].u_fa/a_1072_156# VGND nfet_05v0 ad=0 pd=0 as=0 ps=0 w=0.38u l=0.6u
X301 bitslice\[15\].u_fa/a_3048_156# b[15] bitslice\[15\].u_fa/a_952_112# VGND nfet_05v0 ad=0 pd=0 as=0 ps=0 w=0.38u l=0.6u
X302 VGND bitslice\[15\].u_fa/CI bitslice\[15\].u_fa/a_1072_156# VGND nfet_05v0 ad=0 pd=0 as=0 ps=0 w=0.38u l=0.6u
X303 bitslice\[15\].u_fa/a_2012_472# a[15] VPWR VPWR pfet_05v0 ad=0 pd=0 as=0 ps=0 w=0.7u l=0.5u
X304 bitslice\[4\].u_fa/a_1072_496# b[4] VPWR VPWR pfet_05v0 ad=0.7524p pd=4.92u as=0 ps=0 w=0.66u l=0.5u
X305 bitslice\[4\].u_fa/a_512_156# a[4] VGND VGND nfet_05v0 ad=91.2f pd=1.24u as=0 ps=0 w=0.38u l=0.6u
X306 bitslice\[4\].u_fa/a_124_46# bitslice\[4\].u_fa/CI bitslice\[4\].u_fa/a_680_496# VPWR pfet_05v0 ad=0.4092p pd=2.56u as=0.2244p ps=2u w=0.66u l=0.5u
X307 bitslice\[4\].u_fa/a_3028_472# b[4] bitslice\[4\].u_fa/a_952_112# VPWR pfet_05v0 ad=0.238p pd=2.08u as=0.434p ps=2.64u w=0.7u l=0.5u
X308 VPWR bitslice\[4\].u_fa/CI bitslice\[4\].u_fa/a_1072_496# VPWR pfet_05v0 ad=0 pd=0 as=0 ps=0 w=0.66u l=0.5u
X309 bitslice\[4\].u_fa/a_1072_156# b[4] VGND VGND nfet_05v0 ad=0.3952p pd=3.6u as=0 ps=0 w=0.38u l=0.6u
X310 bitslice\[4\].u_fa/a_680_496# b[4] bitslice\[4\].u_fa/a_512_496# VPWR pfet_05v0 ad=0 pd=0 as=0.2244p ps=2u w=0.66u l=0.5u
X311 bitslice\[4\].u_fa/a_1072_156# bitslice\[4\].u_fa/a_952_112# bitslice\[4\].u_fa/a_124_46# VGND nfet_05v0 ad=0 pd=0 as=0.1976p ps=1.8u w=0.38u l=0.6u
X312 VGND a[4] bitslice\[4\].u_fa/a_3048_156# VGND nfet_05v0 ad=0 pd=0 as=91.2f ps=1.24u w=0.38u l=0.6u
X313 VPWR a[4] bitslice\[4\].u_fa/a_1072_496# VPWR pfet_05v0 ad=0 pd=0 as=0 ps=0 w=0.66u l=0.5u
X314 bitslice\[4\].u_fa/a_952_112# bitslice\[4\].u_fa/CI bitslice\[4\].u_fa/a_1992_156# VGND nfet_05v0 ad=0.1976p pd=1.8u as=0.5896p ps=4.64u w=0.38u l=0.6u
X315 VPWR bitslice\[4\].u_fa/a_124_46# s[4] VPWR pfet_05v0 ad=0 pd=0 as=0.5346p ps=3.31u w=1.215u l=0.5u
X316 VPWR a[4] bitslice\[4\].u_fa/a_3028_472# VPWR pfet_05v0 ad=0 pd=0 as=0 ps=0 w=0.7u l=0.5u
X317 bitslice\[4\].u_fa/a_952_112# bitslice\[4\].u_fa/CI bitslice\[4\].u_fa/a_2012_472# VPWR pfet_05v0 ad=0 pd=0 as=1.05p ps=5.8u w=0.7u l=0.5u
X318 bitslice\[5\].u_fa/CI bitslice\[4\].u_fa/a_952_112# VGND VGND nfet_05v0 ad=0.3586p pd=2.51u as=0 ps=0 w=0.815u l=0.6u
X319 VPWR b[4] bitslice\[4\].u_fa/a_2012_472# VPWR pfet_05v0 ad=0 pd=0 as=0 ps=0 w=0.7u l=0.5u
X320 VGND bitslice\[4\].u_fa/a_124_46# s[4] VGND nfet_05v0 ad=0 pd=0 as=0.3124p ps=2.3u w=0.71u l=0.6u
X321 bitslice\[4\].u_fa/a_1072_496# bitslice\[4\].u_fa/a_952_112# bitslice\[4\].u_fa/a_124_46# VPWR pfet_05v0 ad=0 pd=0 as=0 ps=0 w=0.66u l=0.5u
X322 bitslice\[4\].u_fa/a_512_496# a[4] VPWR VPWR pfet_05v0 ad=0 pd=0 as=0 ps=0 w=0.66u l=0.5u
X323 VGND b[4] bitslice\[4\].u_fa/a_1992_156# VGND nfet_05v0 ad=0 pd=0 as=0 ps=0 w=0.38u l=0.6u
X324 bitslice\[4\].u_fa/a_124_46# bitslice\[4\].u_fa/CI bitslice\[4\].u_fa/a_680_156# VGND nfet_05v0 ad=0 pd=0 as=91.2f ps=1.24u w=0.38u l=0.6u
X325 bitslice\[4\].u_fa/a_680_156# b[4] bitslice\[4\].u_fa/a_512_156# VGND nfet_05v0 ad=0 pd=0 as=0 ps=0 w=0.38u l=0.6u
X326 bitslice\[5\].u_fa/CI bitslice\[4\].u_fa/a_952_112# VPWR VPWR pfet_05v0 ad=0.5346p pd=3.31u as=0 ps=0 w=1.215u l=0.5u
X327 bitslice\[4\].u_fa/a_1992_156# a[4] VGND VGND nfet_05v0 ad=0 pd=0 as=0 ps=0 w=0.38u l=0.6u
X328 VGND a[4] bitslice\[4\].u_fa/a_1072_156# VGND nfet_05v0 ad=0 pd=0 as=0 ps=0 w=0.38u l=0.6u
X329 bitslice\[4\].u_fa/a_3048_156# b[4] bitslice\[4\].u_fa/a_952_112# VGND nfet_05v0 ad=0 pd=0 as=0 ps=0 w=0.38u l=0.6u
X330 VGND bitslice\[4\].u_fa/CI bitslice\[4\].u_fa/a_1072_156# VGND nfet_05v0 ad=0 pd=0 as=0 ps=0 w=0.38u l=0.6u
X331 bitslice\[4\].u_fa/a_2012_472# a[4] VPWR VPWR pfet_05v0 ad=0 pd=0 as=0 ps=0 w=0.7u l=0.5u
X332 bitslice\[10\].u_fa/a_1072_496# b[10] VPWR VPWR pfet_05v0 ad=0.7524p pd=4.92u as=0 ps=0 w=0.66u l=0.5u
X333 bitslice\[10\].u_fa/a_512_156# a[10] VGND VGND nfet_05v0 ad=91.2f pd=1.24u as=0 ps=0 w=0.38u l=0.6u
X334 bitslice\[10\].u_fa/a_124_46# bitslice\[9\].u_fa/CO bitslice\[10\].u_fa/a_680_496# VPWR pfet_05v0 ad=0.4092p pd=2.56u as=0.2244p ps=2u w=0.66u l=0.5u
X335 bitslice\[10\].u_fa/a_3028_472# b[10] bitslice\[10\].u_fa/a_952_112# VPWR pfet_05v0 ad=0.238p pd=2.08u as=0.434p ps=2.64u w=0.7u l=0.5u
X336 VPWR bitslice\[9\].u_fa/CO bitslice\[10\].u_fa/a_1072_496# VPWR pfet_05v0 ad=0 pd=0 as=0 ps=0 w=0.66u l=0.5u
X337 bitslice\[10\].u_fa/a_1072_156# b[10] VGND VGND nfet_05v0 ad=0.3952p pd=3.6u as=0 ps=0 w=0.38u l=0.6u
X338 bitslice\[10\].u_fa/a_680_496# b[10] bitslice\[10\].u_fa/a_512_496# VPWR pfet_05v0 ad=0 pd=0 as=0.2244p ps=2u w=0.66u l=0.5u
X339 bitslice\[10\].u_fa/a_1072_156# bitslice\[10\].u_fa/a_952_112# bitslice\[10\].u_fa/a_124_46# VGND nfet_05v0 ad=0 pd=0 as=0.1976p ps=1.8u w=0.38u l=0.6u
X340 VGND a[10] bitslice\[10\].u_fa/a_3048_156# VGND nfet_05v0 ad=0 pd=0 as=91.2f ps=1.24u w=0.38u l=0.6u
X341 VPWR a[10] bitslice\[10\].u_fa/a_1072_496# VPWR pfet_05v0 ad=0 pd=0 as=0 ps=0 w=0.66u l=0.5u
X342 bitslice\[10\].u_fa/a_952_112# bitslice\[9\].u_fa/CO bitslice\[10\].u_fa/a_1992_156# VGND nfet_05v0 ad=0.1976p pd=1.8u as=0.5896p ps=4.64u w=0.38u l=0.6u
X343 VPWR bitslice\[10\].u_fa/a_124_46# s[10] VPWR pfet_05v0 ad=0 pd=0 as=0.5346p ps=3.31u w=1.215u l=0.5u
X344 VPWR a[10] bitslice\[10\].u_fa/a_3028_472# VPWR pfet_05v0 ad=0 pd=0 as=0 ps=0 w=0.7u l=0.5u
X345 bitslice\[10\].u_fa/a_952_112# bitslice\[9\].u_fa/CO bitslice\[10\].u_fa/a_2012_472# VPWR pfet_05v0 ad=0 pd=0 as=1.05p ps=5.8u w=0.7u l=0.5u
X346 bitslice\[11\].u_fa/CI bitslice\[10\].u_fa/a_952_112# VGND VGND nfet_05v0 ad=0.3586p pd=2.51u as=0 ps=0 w=0.815u l=0.6u
X347 VPWR b[10] bitslice\[10\].u_fa/a_2012_472# VPWR pfet_05v0 ad=0 pd=0 as=0 ps=0 w=0.7u l=0.5u
X348 VGND bitslice\[10\].u_fa/a_124_46# s[10] VGND nfet_05v0 ad=0 pd=0 as=0.3124p ps=2.3u w=0.71u l=0.6u
X349 bitslice\[10\].u_fa/a_1072_496# bitslice\[10\].u_fa/a_952_112# bitslice\[10\].u_fa/a_124_46# VPWR pfet_05v0 ad=0 pd=0 as=0 ps=0 w=0.66u l=0.5u
X350 bitslice\[10\].u_fa/a_512_496# a[10] VPWR VPWR pfet_05v0 ad=0 pd=0 as=0 ps=0 w=0.66u l=0.5u
X351 VGND b[10] bitslice\[10\].u_fa/a_1992_156# VGND nfet_05v0 ad=0 pd=0 as=0 ps=0 w=0.38u l=0.6u
X352 bitslice\[10\].u_fa/a_124_46# bitslice\[9\].u_fa/CO bitslice\[10\].u_fa/a_680_156# VGND nfet_05v0 ad=0 pd=0 as=91.2f ps=1.24u w=0.38u l=0.6u
X353 bitslice\[10\].u_fa/a_680_156# b[10] bitslice\[10\].u_fa/a_512_156# VGND nfet_05v0 ad=0 pd=0 as=0 ps=0 w=0.38u l=0.6u
X354 bitslice\[11\].u_fa/CI bitslice\[10\].u_fa/a_952_112# VPWR VPWR pfet_05v0 ad=0.5346p pd=3.31u as=0 ps=0 w=1.215u l=0.5u
X355 bitslice\[10\].u_fa/a_1992_156# a[10] VGND VGND nfet_05v0 ad=0 pd=0 as=0 ps=0 w=0.38u l=0.6u
X356 VGND a[10] bitslice\[10\].u_fa/a_1072_156# VGND nfet_05v0 ad=0 pd=0 as=0 ps=0 w=0.38u l=0.6u
X357 bitslice\[10\].u_fa/a_3048_156# b[10] bitslice\[10\].u_fa/a_952_112# VGND nfet_05v0 ad=0 pd=0 as=0 ps=0 w=0.38u l=0.6u
X358 VGND bitslice\[9\].u_fa/CO bitslice\[10\].u_fa/a_1072_156# VGND nfet_05v0 ad=0 pd=0 as=0 ps=0 w=0.38u l=0.6u
X359 bitslice\[10\].u_fa/a_2012_472# a[10] VPWR VPWR pfet_05v0 ad=0 pd=0 as=0 ps=0 w=0.7u l=0.5u
X360 bitslice\[16\].u_fa/a_1072_496# b[16] VPWR VPWR pfet_05v0 ad=0.7524p pd=4.92u as=0 ps=0 w=0.66u l=0.5u
X361 bitslice\[16\].u_fa/a_512_156# a[16] VGND VGND nfet_05v0 ad=91.2f pd=1.24u as=0 ps=0 w=0.38u l=0.6u
X362 bitslice\[16\].u_fa/a_124_46# bitslice\[16\].u_fa/CI bitslice\[16\].u_fa/a_680_496# VPWR pfet_05v0 ad=0.4092p pd=2.56u as=0.2244p ps=2u w=0.66u l=0.5u
X363 bitslice\[16\].u_fa/a_3028_472# b[16] bitslice\[16\].u_fa/a_952_112# VPWR pfet_05v0 ad=0.238p pd=2.08u as=0.434p ps=2.64u w=0.7u l=0.5u
X364 VPWR bitslice\[16\].u_fa/CI bitslice\[16\].u_fa/a_1072_496# VPWR pfet_05v0 ad=0 pd=0 as=0 ps=0 w=0.66u l=0.5u
X365 bitslice\[16\].u_fa/a_1072_156# b[16] VGND VGND nfet_05v0 ad=0.3952p pd=3.6u as=0 ps=0 w=0.38u l=0.6u
X366 bitslice\[16\].u_fa/a_680_496# b[16] bitslice\[16\].u_fa/a_512_496# VPWR pfet_05v0 ad=0 pd=0 as=0.2244p ps=2u w=0.66u l=0.5u
X367 bitslice\[16\].u_fa/a_1072_156# bitslice\[16\].u_fa/a_952_112# bitslice\[16\].u_fa/a_124_46# VGND nfet_05v0 ad=0 pd=0 as=0.1976p ps=1.8u w=0.38u l=0.6u
X368 VGND a[16] bitslice\[16\].u_fa/a_3048_156# VGND nfet_05v0 ad=0 pd=0 as=91.2f ps=1.24u w=0.38u l=0.6u
X369 VPWR a[16] bitslice\[16\].u_fa/a_1072_496# VPWR pfet_05v0 ad=0 pd=0 as=0 ps=0 w=0.66u l=0.5u
X370 bitslice\[16\].u_fa/a_952_112# bitslice\[16\].u_fa/CI bitslice\[16\].u_fa/a_1992_156# VGND nfet_05v0 ad=0.1976p pd=1.8u as=0.5896p ps=4.64u w=0.38u l=0.6u
X371 VPWR bitslice\[16\].u_fa/a_124_46# s[16] VPWR pfet_05v0 ad=0 pd=0 as=0.5346p ps=3.31u w=1.215u l=0.5u
X372 VPWR a[16] bitslice\[16\].u_fa/a_3028_472# VPWR pfet_05v0 ad=0 pd=0 as=0 ps=0 w=0.7u l=0.5u
X373 bitslice\[16\].u_fa/a_952_112# bitslice\[16\].u_fa/CI bitslice\[16\].u_fa/a_2012_472# VPWR pfet_05v0 ad=0 pd=0 as=1.05p ps=5.8u w=0.7u l=0.5u
X374 bitslice\[17\].u_fa/CI bitslice\[16\].u_fa/a_952_112# VGND VGND nfet_05v0 ad=0.3586p pd=2.51u as=0 ps=0 w=0.815u l=0.6u
X375 VPWR b[16] bitslice\[16\].u_fa/a_2012_472# VPWR pfet_05v0 ad=0 pd=0 as=0 ps=0 w=0.7u l=0.5u
X376 VGND bitslice\[16\].u_fa/a_124_46# s[16] VGND nfet_05v0 ad=0 pd=0 as=0.3124p ps=2.3u w=0.71u l=0.6u
X377 bitslice\[16\].u_fa/a_1072_496# bitslice\[16\].u_fa/a_952_112# bitslice\[16\].u_fa/a_124_46# VPWR pfet_05v0 ad=0 pd=0 as=0 ps=0 w=0.66u l=0.5u
X378 bitslice\[16\].u_fa/a_512_496# a[16] VPWR VPWR pfet_05v0 ad=0 pd=0 as=0 ps=0 w=0.66u l=0.5u
X379 VGND b[16] bitslice\[16\].u_fa/a_1992_156# VGND nfet_05v0 ad=0 pd=0 as=0 ps=0 w=0.38u l=0.6u
X380 bitslice\[16\].u_fa/a_124_46# bitslice\[16\].u_fa/CI bitslice\[16\].u_fa/a_680_156# VGND nfet_05v0 ad=0 pd=0 as=91.2f ps=1.24u w=0.38u l=0.6u
X381 bitslice\[16\].u_fa/a_680_156# b[16] bitslice\[16\].u_fa/a_512_156# VGND nfet_05v0 ad=0 pd=0 as=0 ps=0 w=0.38u l=0.6u
X382 bitslice\[17\].u_fa/CI bitslice\[16\].u_fa/a_952_112# VPWR VPWR pfet_05v0 ad=0.5346p pd=3.31u as=0 ps=0 w=1.215u l=0.5u
X383 bitslice\[16\].u_fa/a_1992_156# a[16] VGND VGND nfet_05v0 ad=0 pd=0 as=0 ps=0 w=0.38u l=0.6u
X384 VGND a[16] bitslice\[16\].u_fa/a_1072_156# VGND nfet_05v0 ad=0 pd=0 as=0 ps=0 w=0.38u l=0.6u
X385 bitslice\[16\].u_fa/a_3048_156# b[16] bitslice\[16\].u_fa/a_952_112# VGND nfet_05v0 ad=0 pd=0 as=0 ps=0 w=0.38u l=0.6u
X386 VGND bitslice\[16\].u_fa/CI bitslice\[16\].u_fa/a_1072_156# VGND nfet_05v0 ad=0 pd=0 as=0 ps=0 w=0.38u l=0.6u
X387 bitslice\[16\].u_fa/a_2012_472# a[16] VPWR VPWR pfet_05v0 ad=0 pd=0 as=0 ps=0 w=0.7u l=0.5u
X388 bitslice\[5\].u_fa/a_1072_496# b[5] VPWR VPWR pfet_05v0 ad=0.7524p pd=4.92u as=0 ps=0 w=0.66u l=0.5u
X389 bitslice\[5\].u_fa/a_512_156# a[5] VGND VGND nfet_05v0 ad=91.2f pd=1.24u as=0 ps=0 w=0.38u l=0.6u
X390 bitslice\[5\].u_fa/a_124_46# bitslice\[5\].u_fa/CI bitslice\[5\].u_fa/a_680_496# VPWR pfet_05v0 ad=0.4092p pd=2.56u as=0.2244p ps=2u w=0.66u l=0.5u
X391 bitslice\[5\].u_fa/a_3028_472# b[5] bitslice\[5\].u_fa/a_952_112# VPWR pfet_05v0 ad=0.238p pd=2.08u as=0.434p ps=2.64u w=0.7u l=0.5u
X392 VPWR bitslice\[5\].u_fa/CI bitslice\[5\].u_fa/a_1072_496# VPWR pfet_05v0 ad=0 pd=0 as=0 ps=0 w=0.66u l=0.5u
X393 bitslice\[5\].u_fa/a_1072_156# b[5] VGND VGND nfet_05v0 ad=0.3952p pd=3.6u as=0 ps=0 w=0.38u l=0.6u
X394 bitslice\[5\].u_fa/a_680_496# b[5] bitslice\[5\].u_fa/a_512_496# VPWR pfet_05v0 ad=0 pd=0 as=0.2244p ps=2u w=0.66u l=0.5u
X395 bitslice\[5\].u_fa/a_1072_156# bitslice\[5\].u_fa/a_952_112# bitslice\[5\].u_fa/a_124_46# VGND nfet_05v0 ad=0 pd=0 as=0.1976p ps=1.8u w=0.38u l=0.6u
X396 VGND a[5] bitslice\[5\].u_fa/a_3048_156# VGND nfet_05v0 ad=0 pd=0 as=91.2f ps=1.24u w=0.38u l=0.6u
X397 VPWR a[5] bitslice\[5\].u_fa/a_1072_496# VPWR pfet_05v0 ad=0 pd=0 as=0 ps=0 w=0.66u l=0.5u
X398 bitslice\[5\].u_fa/a_952_112# bitslice\[5\].u_fa/CI bitslice\[5\].u_fa/a_1992_156# VGND nfet_05v0 ad=0.1976p pd=1.8u as=0.5896p ps=4.64u w=0.38u l=0.6u
X399 VPWR bitslice\[5\].u_fa/a_124_46# s[5] VPWR pfet_05v0 ad=0 pd=0 as=0.5346p ps=3.31u w=1.215u l=0.5u
X400 VPWR a[5] bitslice\[5\].u_fa/a_3028_472# VPWR pfet_05v0 ad=0 pd=0 as=0 ps=0 w=0.7u l=0.5u
X401 bitslice\[5\].u_fa/a_952_112# bitslice\[5\].u_fa/CI bitslice\[5\].u_fa/a_2012_472# VPWR pfet_05v0 ad=0 pd=0 as=1.05p ps=5.8u w=0.7u l=0.5u
X402 bitslice\[6\].u_fa/CI bitslice\[5\].u_fa/a_952_112# VGND VGND nfet_05v0 ad=0.3586p pd=2.51u as=0 ps=0 w=0.815u l=0.6u
X403 VPWR b[5] bitslice\[5\].u_fa/a_2012_472# VPWR pfet_05v0 ad=0 pd=0 as=0 ps=0 w=0.7u l=0.5u
X404 VGND bitslice\[5\].u_fa/a_124_46# s[5] VGND nfet_05v0 ad=0 pd=0 as=0.3124p ps=2.3u w=0.71u l=0.6u
X405 bitslice\[5\].u_fa/a_1072_496# bitslice\[5\].u_fa/a_952_112# bitslice\[5\].u_fa/a_124_46# VPWR pfet_05v0 ad=0 pd=0 as=0 ps=0 w=0.66u l=0.5u
X406 bitslice\[5\].u_fa/a_512_496# a[5] VPWR VPWR pfet_05v0 ad=0 pd=0 as=0 ps=0 w=0.66u l=0.5u
X407 VGND b[5] bitslice\[5\].u_fa/a_1992_156# VGND nfet_05v0 ad=0 pd=0 as=0 ps=0 w=0.38u l=0.6u
X408 bitslice\[5\].u_fa/a_124_46# bitslice\[5\].u_fa/CI bitslice\[5\].u_fa/a_680_156# VGND nfet_05v0 ad=0 pd=0 as=91.2f ps=1.24u w=0.38u l=0.6u
X409 bitslice\[5\].u_fa/a_680_156# b[5] bitslice\[5\].u_fa/a_512_156# VGND nfet_05v0 ad=0 pd=0 as=0 ps=0 w=0.38u l=0.6u
X410 bitslice\[6\].u_fa/CI bitslice\[5\].u_fa/a_952_112# VPWR VPWR pfet_05v0 ad=0.5346p pd=3.31u as=0 ps=0 w=1.215u l=0.5u
X411 bitslice\[5\].u_fa/a_1992_156# a[5] VGND VGND nfet_05v0 ad=0 pd=0 as=0 ps=0 w=0.38u l=0.6u
X412 VGND a[5] bitslice\[5\].u_fa/a_1072_156# VGND nfet_05v0 ad=0 pd=0 as=0 ps=0 w=0.38u l=0.6u
X413 bitslice\[5\].u_fa/a_3048_156# b[5] bitslice\[5\].u_fa/a_952_112# VGND nfet_05v0 ad=0 pd=0 as=0 ps=0 w=0.38u l=0.6u
X414 VGND bitslice\[5\].u_fa/CI bitslice\[5\].u_fa/a_1072_156# VGND nfet_05v0 ad=0 pd=0 as=0 ps=0 w=0.38u l=0.6u
X415 bitslice\[5\].u_fa/a_2012_472# a[5] VPWR VPWR pfet_05v0 ad=0 pd=0 as=0 ps=0 w=0.7u l=0.5u
X416 bitslice\[11\].u_fa/a_1072_496# b[11] VPWR VPWR pfet_05v0 ad=0.7524p pd=4.92u as=0 ps=0 w=0.66u l=0.5u
X417 bitslice\[11\].u_fa/a_512_156# a[11] VGND VGND nfet_05v0 ad=91.2f pd=1.24u as=0 ps=0 w=0.38u l=0.6u
X418 bitslice\[11\].u_fa/a_124_46# bitslice\[11\].u_fa/CI bitslice\[11\].u_fa/a_680_496# VPWR pfet_05v0 ad=0.4092p pd=2.56u as=0.2244p ps=2u w=0.66u l=0.5u
X419 bitslice\[11\].u_fa/a_3028_472# b[11] bitslice\[11\].u_fa/a_952_112# VPWR pfet_05v0 ad=0.238p pd=2.08u as=0.434p ps=2.64u w=0.7u l=0.5u
X420 VPWR bitslice\[11\].u_fa/CI bitslice\[11\].u_fa/a_1072_496# VPWR pfet_05v0 ad=0 pd=0 as=0 ps=0 w=0.66u l=0.5u
X421 bitslice\[11\].u_fa/a_1072_156# b[11] VGND VGND nfet_05v0 ad=0.3952p pd=3.6u as=0 ps=0 w=0.38u l=0.6u
X422 bitslice\[11\].u_fa/a_680_496# b[11] bitslice\[11\].u_fa/a_512_496# VPWR pfet_05v0 ad=0 pd=0 as=0.2244p ps=2u w=0.66u l=0.5u
X423 bitslice\[11\].u_fa/a_1072_156# bitslice\[11\].u_fa/a_952_112# bitslice\[11\].u_fa/a_124_46# VGND nfet_05v0 ad=0 pd=0 as=0.1976p ps=1.8u w=0.38u l=0.6u
X424 VGND a[11] bitslice\[11\].u_fa/a_3048_156# VGND nfet_05v0 ad=0 pd=0 as=91.2f ps=1.24u w=0.38u l=0.6u
X425 VPWR a[11] bitslice\[11\].u_fa/a_1072_496# VPWR pfet_05v0 ad=0 pd=0 as=0 ps=0 w=0.66u l=0.5u
X426 bitslice\[11\].u_fa/a_952_112# bitslice\[11\].u_fa/CI bitslice\[11\].u_fa/a_1992_156# VGND nfet_05v0 ad=0.1976p pd=1.8u as=0.5896p ps=4.64u w=0.38u l=0.6u
X427 VPWR bitslice\[11\].u_fa/a_124_46# s[11] VPWR pfet_05v0 ad=0 pd=0 as=0.5346p ps=3.31u w=1.215u l=0.5u
X428 VPWR a[11] bitslice\[11\].u_fa/a_3028_472# VPWR pfet_05v0 ad=0 pd=0 as=0 ps=0 w=0.7u l=0.5u
X429 bitslice\[11\].u_fa/a_952_112# bitslice\[11\].u_fa/CI bitslice\[11\].u_fa/a_2012_472# VPWR pfet_05v0 ad=0 pd=0 as=1.05p ps=5.8u w=0.7u l=0.5u
X430 bitslice\[12\].u_fa/CI bitslice\[11\].u_fa/a_952_112# VGND VGND nfet_05v0 ad=0.3586p pd=2.51u as=0 ps=0 w=0.815u l=0.6u
X431 VPWR b[11] bitslice\[11\].u_fa/a_2012_472# VPWR pfet_05v0 ad=0 pd=0 as=0 ps=0 w=0.7u l=0.5u
X432 VGND bitslice\[11\].u_fa/a_124_46# s[11] VGND nfet_05v0 ad=0 pd=0 as=0.3124p ps=2.3u w=0.71u l=0.6u
X433 bitslice\[11\].u_fa/a_1072_496# bitslice\[11\].u_fa/a_952_112# bitslice\[11\].u_fa/a_124_46# VPWR pfet_05v0 ad=0 pd=0 as=0 ps=0 w=0.66u l=0.5u
X434 bitslice\[11\].u_fa/a_512_496# a[11] VPWR VPWR pfet_05v0 ad=0 pd=0 as=0 ps=0 w=0.66u l=0.5u
X435 VGND b[11] bitslice\[11\].u_fa/a_1992_156# VGND nfet_05v0 ad=0 pd=0 as=0 ps=0 w=0.38u l=0.6u
X436 bitslice\[11\].u_fa/a_124_46# bitslice\[11\].u_fa/CI bitslice\[11\].u_fa/a_680_156# VGND nfet_05v0 ad=0 pd=0 as=91.2f ps=1.24u w=0.38u l=0.6u
X437 bitslice\[11\].u_fa/a_680_156# b[11] bitslice\[11\].u_fa/a_512_156# VGND nfet_05v0 ad=0 pd=0 as=0 ps=0 w=0.38u l=0.6u
X438 bitslice\[12\].u_fa/CI bitslice\[11\].u_fa/a_952_112# VPWR VPWR pfet_05v0 ad=0.5346p pd=3.31u as=0 ps=0 w=1.215u l=0.5u
X439 bitslice\[11\].u_fa/a_1992_156# a[11] VGND VGND nfet_05v0 ad=0 pd=0 as=0 ps=0 w=0.38u l=0.6u
X440 VGND a[11] bitslice\[11\].u_fa/a_1072_156# VGND nfet_05v0 ad=0 pd=0 as=0 ps=0 w=0.38u l=0.6u
X441 bitslice\[11\].u_fa/a_3048_156# b[11] bitslice\[11\].u_fa/a_952_112# VGND nfet_05v0 ad=0 pd=0 as=0 ps=0 w=0.38u l=0.6u
X442 VGND bitslice\[11\].u_fa/CI bitslice\[11\].u_fa/a_1072_156# VGND nfet_05v0 ad=0 pd=0 as=0 ps=0 w=0.38u l=0.6u
X443 bitslice\[11\].u_fa/a_2012_472# a[11] VPWR VPWR pfet_05v0 ad=0 pd=0 as=0 ps=0 w=0.7u l=0.5u
X444 bitslice\[17\].u_fa/a_1072_496# b[17] VPWR VPWR pfet_05v0 ad=0.7524p pd=4.92u as=0 ps=0 w=0.66u l=0.5u
X445 bitslice\[17\].u_fa/a_512_156# a[17] VGND VGND nfet_05v0 ad=91.2f pd=1.24u as=0 ps=0 w=0.38u l=0.6u
X446 bitslice\[17\].u_fa/a_124_46# bitslice\[17\].u_fa/CI bitslice\[17\].u_fa/a_680_496# VPWR pfet_05v0 ad=0.4092p pd=2.56u as=0.2244p ps=2u w=0.66u l=0.5u
X447 bitslice\[17\].u_fa/a_3028_472# b[17] bitslice\[17\].u_fa/a_952_112# VPWR pfet_05v0 ad=0.238p pd=2.08u as=0.434p ps=2.64u w=0.7u l=0.5u
X448 VPWR bitslice\[17\].u_fa/CI bitslice\[17\].u_fa/a_1072_496# VPWR pfet_05v0 ad=0 pd=0 as=0 ps=0 w=0.66u l=0.5u
X449 bitslice\[17\].u_fa/a_1072_156# b[17] VGND VGND nfet_05v0 ad=0.3952p pd=3.6u as=0 ps=0 w=0.38u l=0.6u
X450 bitslice\[17\].u_fa/a_680_496# b[17] bitslice\[17\].u_fa/a_512_496# VPWR pfet_05v0 ad=0 pd=0 as=0.2244p ps=2u w=0.66u l=0.5u
X451 bitslice\[17\].u_fa/a_1072_156# bitslice\[17\].u_fa/a_952_112# bitslice\[17\].u_fa/a_124_46# VGND nfet_05v0 ad=0 pd=0 as=0.1976p ps=1.8u w=0.38u l=0.6u
X452 VGND a[17] bitslice\[17\].u_fa/a_3048_156# VGND nfet_05v0 ad=0 pd=0 as=91.2f ps=1.24u w=0.38u l=0.6u
X453 VPWR a[17] bitslice\[17\].u_fa/a_1072_496# VPWR pfet_05v0 ad=0 pd=0 as=0 ps=0 w=0.66u l=0.5u
X454 bitslice\[17\].u_fa/a_952_112# bitslice\[17\].u_fa/CI bitslice\[17\].u_fa/a_1992_156# VGND nfet_05v0 ad=0.1976p pd=1.8u as=0.5896p ps=4.64u w=0.38u l=0.6u
X455 VPWR bitslice\[17\].u_fa/a_124_46# s[17] VPWR pfet_05v0 ad=0 pd=0 as=0.5346p ps=3.31u w=1.215u l=0.5u
X456 VPWR a[17] bitslice\[17\].u_fa/a_3028_472# VPWR pfet_05v0 ad=0 pd=0 as=0 ps=0 w=0.7u l=0.5u
X457 bitslice\[17\].u_fa/a_952_112# bitslice\[17\].u_fa/CI bitslice\[17\].u_fa/a_2012_472# VPWR pfet_05v0 ad=0 pd=0 as=1.05p ps=5.8u w=0.7u l=0.5u
X458 bitslice\[18\].u_fa/CI bitslice\[17\].u_fa/a_952_112# VGND VGND nfet_05v0 ad=0.3586p pd=2.51u as=0 ps=0 w=0.815u l=0.6u
X459 VPWR b[17] bitslice\[17\].u_fa/a_2012_472# VPWR pfet_05v0 ad=0 pd=0 as=0 ps=0 w=0.7u l=0.5u
X460 VGND bitslice\[17\].u_fa/a_124_46# s[17] VGND nfet_05v0 ad=0 pd=0 as=0.3124p ps=2.3u w=0.71u l=0.6u
X461 bitslice\[17\].u_fa/a_1072_496# bitslice\[17\].u_fa/a_952_112# bitslice\[17\].u_fa/a_124_46# VPWR pfet_05v0 ad=0 pd=0 as=0 ps=0 w=0.66u l=0.5u
X462 bitslice\[17\].u_fa/a_512_496# a[17] VPWR VPWR pfet_05v0 ad=0 pd=0 as=0 ps=0 w=0.66u l=0.5u
X463 VGND b[17] bitslice\[17\].u_fa/a_1992_156# VGND nfet_05v0 ad=0 pd=0 as=0 ps=0 w=0.38u l=0.6u
X464 bitslice\[17\].u_fa/a_124_46# bitslice\[17\].u_fa/CI bitslice\[17\].u_fa/a_680_156# VGND nfet_05v0 ad=0 pd=0 as=91.2f ps=1.24u w=0.38u l=0.6u
X465 bitslice\[17\].u_fa/a_680_156# b[17] bitslice\[17\].u_fa/a_512_156# VGND nfet_05v0 ad=0 pd=0 as=0 ps=0 w=0.38u l=0.6u
X466 bitslice\[18\].u_fa/CI bitslice\[17\].u_fa/a_952_112# VPWR VPWR pfet_05v0 ad=0.5346p pd=3.31u as=0 ps=0 w=1.215u l=0.5u
X467 bitslice\[17\].u_fa/a_1992_156# a[17] VGND VGND nfet_05v0 ad=0 pd=0 as=0 ps=0 w=0.38u l=0.6u
X468 VGND a[17] bitslice\[17\].u_fa/a_1072_156# VGND nfet_05v0 ad=0 pd=0 as=0 ps=0 w=0.38u l=0.6u
X469 bitslice\[17\].u_fa/a_3048_156# b[17] bitslice\[17\].u_fa/a_952_112# VGND nfet_05v0 ad=0 pd=0 as=0 ps=0 w=0.38u l=0.6u
X470 VGND bitslice\[17\].u_fa/CI bitslice\[17\].u_fa/a_1072_156# VGND nfet_05v0 ad=0 pd=0 as=0 ps=0 w=0.38u l=0.6u
X471 bitslice\[17\].u_fa/a_2012_472# a[17] VPWR VPWR pfet_05v0 ad=0 pd=0 as=0 ps=0 w=0.7u l=0.5u
X472 bitslice\[0\].u_fa/a_1072_496# b[0] VPWR VPWR pfet_05v0 ad=0.7524p pd=4.92u as=0 ps=0 w=0.66u l=0.5u
X473 bitslice\[0\].u_fa/a_512_156# a[0] VGND VGND nfet_05v0 ad=91.2f pd=1.24u as=0 ps=0 w=0.38u l=0.6u
X474 bitslice\[0\].u_fa/a_124_46# cin bitslice\[0\].u_fa/a_680_496# VPWR pfet_05v0 ad=0.4092p pd=2.56u as=0.2244p ps=2u w=0.66u l=0.5u
X475 bitslice\[0\].u_fa/a_3028_472# b[0] bitslice\[0\].u_fa/a_952_112# VPWR pfet_05v0 ad=0.238p pd=2.08u as=0.434p ps=2.64u w=0.7u l=0.5u
X476 VPWR cin bitslice\[0\].u_fa/a_1072_496# VPWR pfet_05v0 ad=0 pd=0 as=0 ps=0 w=0.66u l=0.5u
X477 bitslice\[0\].u_fa/a_1072_156# b[0] VGND VGND nfet_05v0 ad=0.3952p pd=3.6u as=0 ps=0 w=0.38u l=0.6u
X478 bitslice\[0\].u_fa/a_680_496# b[0] bitslice\[0\].u_fa/a_512_496# VPWR pfet_05v0 ad=0 pd=0 as=0.2244p ps=2u w=0.66u l=0.5u
X479 bitslice\[0\].u_fa/a_1072_156# bitslice\[0\].u_fa/a_952_112# bitslice\[0\].u_fa/a_124_46# VGND nfet_05v0 ad=0 pd=0 as=0.1976p ps=1.8u w=0.38u l=0.6u
X480 VGND a[0] bitslice\[0\].u_fa/a_3048_156# VGND nfet_05v0 ad=0 pd=0 as=91.2f ps=1.24u w=0.38u l=0.6u
X481 VPWR a[0] bitslice\[0\].u_fa/a_1072_496# VPWR pfet_05v0 ad=0 pd=0 as=0 ps=0 w=0.66u l=0.5u
X482 bitslice\[0\].u_fa/a_952_112# cin bitslice\[0\].u_fa/a_1992_156# VGND nfet_05v0 ad=0.1976p pd=1.8u as=0.5896p ps=4.64u w=0.38u l=0.6u
X483 VPWR bitslice\[0\].u_fa/a_124_46# s[0] VPWR pfet_05v0 ad=0 pd=0 as=0.5346p ps=3.31u w=1.215u l=0.5u
X484 VPWR a[0] bitslice\[0\].u_fa/a_3028_472# VPWR pfet_05v0 ad=0 pd=0 as=0 ps=0 w=0.7u l=0.5u
X485 bitslice\[0\].u_fa/a_952_112# cin bitslice\[0\].u_fa/a_2012_472# VPWR pfet_05v0 ad=0 pd=0 as=1.05p ps=5.8u w=0.7u l=0.5u
X486 bitslice\[1\].u_fa/CI bitslice\[0\].u_fa/a_952_112# VGND VGND nfet_05v0 ad=0.3586p pd=2.51u as=0 ps=0 w=0.815u l=0.6u
X487 VPWR b[0] bitslice\[0\].u_fa/a_2012_472# VPWR pfet_05v0 ad=0 pd=0 as=0 ps=0 w=0.7u l=0.5u
X488 VGND bitslice\[0\].u_fa/a_124_46# s[0] VGND nfet_05v0 ad=0 pd=0 as=0.3124p ps=2.3u w=0.71u l=0.6u
X489 bitslice\[0\].u_fa/a_1072_496# bitslice\[0\].u_fa/a_952_112# bitslice\[0\].u_fa/a_124_46# VPWR pfet_05v0 ad=0 pd=0 as=0 ps=0 w=0.66u l=0.5u
X490 bitslice\[0\].u_fa/a_512_496# a[0] VPWR VPWR pfet_05v0 ad=0 pd=0 as=0 ps=0 w=0.66u l=0.5u
X491 VGND b[0] bitslice\[0\].u_fa/a_1992_156# VGND nfet_05v0 ad=0 pd=0 as=0 ps=0 w=0.38u l=0.6u
X492 bitslice\[0\].u_fa/a_124_46# cin bitslice\[0\].u_fa/a_680_156# VGND nfet_05v0 ad=0 pd=0 as=91.2f ps=1.24u w=0.38u l=0.6u
X493 bitslice\[0\].u_fa/a_680_156# b[0] bitslice\[0\].u_fa/a_512_156# VGND nfet_05v0 ad=0 pd=0 as=0 ps=0 w=0.38u l=0.6u
X494 bitslice\[1\].u_fa/CI bitslice\[0\].u_fa/a_952_112# VPWR VPWR pfet_05v0 ad=0.5346p pd=3.31u as=0 ps=0 w=1.215u l=0.5u
X495 bitslice\[0\].u_fa/a_1992_156# a[0] VGND VGND nfet_05v0 ad=0 pd=0 as=0 ps=0 w=0.38u l=0.6u
X496 VGND a[0] bitslice\[0\].u_fa/a_1072_156# VGND nfet_05v0 ad=0 pd=0 as=0 ps=0 w=0.38u l=0.6u
X497 bitslice\[0\].u_fa/a_3048_156# b[0] bitslice\[0\].u_fa/a_952_112# VGND nfet_05v0 ad=0 pd=0 as=0 ps=0 w=0.38u l=0.6u
X498 VGND cin bitslice\[0\].u_fa/a_1072_156# VGND nfet_05v0 ad=0 pd=0 as=0 ps=0 w=0.38u l=0.6u
X499 bitslice\[0\].u_fa/a_2012_472# a[0] VPWR VPWR pfet_05v0 ad=0 pd=0 as=0 ps=0 w=0.7u l=0.5u
X500 bitslice\[6\].u_fa/a_1072_496# b[6] VPWR VPWR pfet_05v0 ad=0.7524p pd=4.92u as=0 ps=0 w=0.66u l=0.5u
X501 bitslice\[6\].u_fa/a_512_156# a[6] VGND VGND nfet_05v0 ad=91.2f pd=1.24u as=0 ps=0 w=0.38u l=0.6u
X502 bitslice\[6\].u_fa/a_124_46# bitslice\[6\].u_fa/CI bitslice\[6\].u_fa/a_680_496# VPWR pfet_05v0 ad=0.4092p pd=2.56u as=0.2244p ps=2u w=0.66u l=0.5u
X503 bitslice\[6\].u_fa/a_3028_472# b[6] bitslice\[6\].u_fa/a_952_112# VPWR pfet_05v0 ad=0.238p pd=2.08u as=0.434p ps=2.64u w=0.7u l=0.5u
X504 VPWR bitslice\[6\].u_fa/CI bitslice\[6\].u_fa/a_1072_496# VPWR pfet_05v0 ad=0 pd=0 as=0 ps=0 w=0.66u l=0.5u
X505 bitslice\[6\].u_fa/a_1072_156# b[6] VGND VGND nfet_05v0 ad=0.3952p pd=3.6u as=0 ps=0 w=0.38u l=0.6u
X506 bitslice\[6\].u_fa/a_680_496# b[6] bitslice\[6\].u_fa/a_512_496# VPWR pfet_05v0 ad=0 pd=0 as=0.2244p ps=2u w=0.66u l=0.5u
X507 bitslice\[6\].u_fa/a_1072_156# bitslice\[6\].u_fa/a_952_112# bitslice\[6\].u_fa/a_124_46# VGND nfet_05v0 ad=0 pd=0 as=0.1976p ps=1.8u w=0.38u l=0.6u
X508 VGND a[6] bitslice\[6\].u_fa/a_3048_156# VGND nfet_05v0 ad=0 pd=0 as=91.2f ps=1.24u w=0.38u l=0.6u
X509 VPWR a[6] bitslice\[6\].u_fa/a_1072_496# VPWR pfet_05v0 ad=0 pd=0 as=0 ps=0 w=0.66u l=0.5u
X510 bitslice\[6\].u_fa/a_952_112# bitslice\[6\].u_fa/CI bitslice\[6\].u_fa/a_1992_156# VGND nfet_05v0 ad=0.1976p pd=1.8u as=0.5896p ps=4.64u w=0.38u l=0.6u
X511 VPWR bitslice\[6\].u_fa/a_124_46# s[6] VPWR pfet_05v0 ad=0 pd=0 as=0.5346p ps=3.31u w=1.215u l=0.5u
X512 VPWR a[6] bitslice\[6\].u_fa/a_3028_472# VPWR pfet_05v0 ad=0 pd=0 as=0 ps=0 w=0.7u l=0.5u
X513 bitslice\[6\].u_fa/a_952_112# bitslice\[6\].u_fa/CI bitslice\[6\].u_fa/a_2012_472# VPWR pfet_05v0 ad=0 pd=0 as=1.05p ps=5.8u w=0.7u l=0.5u
X514 bitslice\[7\].u_fa/CI bitslice\[6\].u_fa/a_952_112# VGND VGND nfet_05v0 ad=0.3586p pd=2.51u as=0 ps=0 w=0.815u l=0.6u
X515 VPWR b[6] bitslice\[6\].u_fa/a_2012_472# VPWR pfet_05v0 ad=0 pd=0 as=0 ps=0 w=0.7u l=0.5u
X516 VGND bitslice\[6\].u_fa/a_124_46# s[6] VGND nfet_05v0 ad=0 pd=0 as=0.3124p ps=2.3u w=0.71u l=0.6u
X517 bitslice\[6\].u_fa/a_1072_496# bitslice\[6\].u_fa/a_952_112# bitslice\[6\].u_fa/a_124_46# VPWR pfet_05v0 ad=0 pd=0 as=0 ps=0 w=0.66u l=0.5u
X518 bitslice\[6\].u_fa/a_512_496# a[6] VPWR VPWR pfet_05v0 ad=0 pd=0 as=0 ps=0 w=0.66u l=0.5u
X519 VGND b[6] bitslice\[6\].u_fa/a_1992_156# VGND nfet_05v0 ad=0 pd=0 as=0 ps=0 w=0.38u l=0.6u
X520 bitslice\[6\].u_fa/a_124_46# bitslice\[6\].u_fa/CI bitslice\[6\].u_fa/a_680_156# VGND nfet_05v0 ad=0 pd=0 as=91.2f ps=1.24u w=0.38u l=0.6u
X521 bitslice\[6\].u_fa/a_680_156# b[6] bitslice\[6\].u_fa/a_512_156# VGND nfet_05v0 ad=0 pd=0 as=0 ps=0 w=0.38u l=0.6u
X522 bitslice\[7\].u_fa/CI bitslice\[6\].u_fa/a_952_112# VPWR VPWR pfet_05v0 ad=0.5346p pd=3.31u as=0 ps=0 w=1.215u l=0.5u
X523 bitslice\[6\].u_fa/a_1992_156# a[6] VGND VGND nfet_05v0 ad=0 pd=0 as=0 ps=0 w=0.38u l=0.6u
X524 VGND a[6] bitslice\[6\].u_fa/a_1072_156# VGND nfet_05v0 ad=0 pd=0 as=0 ps=0 w=0.38u l=0.6u
X525 bitslice\[6\].u_fa/a_3048_156# b[6] bitslice\[6\].u_fa/a_952_112# VGND nfet_05v0 ad=0 pd=0 as=0 ps=0 w=0.38u l=0.6u
X526 VGND bitslice\[6\].u_fa/CI bitslice\[6\].u_fa/a_1072_156# VGND nfet_05v0 ad=0 pd=0 as=0 ps=0 w=0.38u l=0.6u
X527 bitslice\[6\].u_fa/a_2012_472# a[6] VPWR VPWR pfet_05v0 ad=0 pd=0 as=0 ps=0 w=0.7u l=0.5u
X528 bitslice\[12\].u_fa/a_1072_496# b[12] VPWR VPWR pfet_05v0 ad=0.7524p pd=4.92u as=0 ps=0 w=0.66u l=0.5u
X529 bitslice\[12\].u_fa/a_512_156# a[12] VGND VGND nfet_05v0 ad=91.2f pd=1.24u as=0 ps=0 w=0.38u l=0.6u
X530 bitslice\[12\].u_fa/a_124_46# bitslice\[12\].u_fa/CI bitslice\[12\].u_fa/a_680_496# VPWR pfet_05v0 ad=0.4092p pd=2.56u as=0.2244p ps=2u w=0.66u l=0.5u
X531 bitslice\[12\].u_fa/a_3028_472# b[12] bitslice\[12\].u_fa/a_952_112# VPWR pfet_05v0 ad=0.238p pd=2.08u as=0.434p ps=2.64u w=0.7u l=0.5u
X532 VPWR bitslice\[12\].u_fa/CI bitslice\[12\].u_fa/a_1072_496# VPWR pfet_05v0 ad=0 pd=0 as=0 ps=0 w=0.66u l=0.5u
X533 bitslice\[12\].u_fa/a_1072_156# b[12] VGND VGND nfet_05v0 ad=0.3952p pd=3.6u as=0 ps=0 w=0.38u l=0.6u
X534 bitslice\[12\].u_fa/a_680_496# b[12] bitslice\[12\].u_fa/a_512_496# VPWR pfet_05v0 ad=0 pd=0 as=0.2244p ps=2u w=0.66u l=0.5u
X535 bitslice\[12\].u_fa/a_1072_156# bitslice\[12\].u_fa/a_952_112# bitslice\[12\].u_fa/a_124_46# VGND nfet_05v0 ad=0 pd=0 as=0.1976p ps=1.8u w=0.38u l=0.6u
X536 VGND a[12] bitslice\[12\].u_fa/a_3048_156# VGND nfet_05v0 ad=0 pd=0 as=91.2f ps=1.24u w=0.38u l=0.6u
X537 VPWR a[12] bitslice\[12\].u_fa/a_1072_496# VPWR pfet_05v0 ad=0 pd=0 as=0 ps=0 w=0.66u l=0.5u
X538 bitslice\[12\].u_fa/a_952_112# bitslice\[12\].u_fa/CI bitslice\[12\].u_fa/a_1992_156# VGND nfet_05v0 ad=0.1976p pd=1.8u as=0.5896p ps=4.64u w=0.38u l=0.6u
X539 VPWR bitslice\[12\].u_fa/a_124_46# s[12] VPWR pfet_05v0 ad=0 pd=0 as=0.5346p ps=3.31u w=1.215u l=0.5u
X540 VPWR a[12] bitslice\[12\].u_fa/a_3028_472# VPWR pfet_05v0 ad=0 pd=0 as=0 ps=0 w=0.7u l=0.5u
X541 bitslice\[12\].u_fa/a_952_112# bitslice\[12\].u_fa/CI bitslice\[12\].u_fa/a_2012_472# VPWR pfet_05v0 ad=0 pd=0 as=1.05p ps=5.8u w=0.7u l=0.5u
X542 bitslice\[13\].u_fa/CI bitslice\[12\].u_fa/a_952_112# VGND VGND nfet_05v0 ad=0.3586p pd=2.51u as=0 ps=0 w=0.815u l=0.6u
X543 VPWR b[12] bitslice\[12\].u_fa/a_2012_472# VPWR pfet_05v0 ad=0 pd=0 as=0 ps=0 w=0.7u l=0.5u
X544 VGND bitslice\[12\].u_fa/a_124_46# s[12] VGND nfet_05v0 ad=0 pd=0 as=0.3124p ps=2.3u w=0.71u l=0.6u
X545 bitslice\[12\].u_fa/a_1072_496# bitslice\[12\].u_fa/a_952_112# bitslice\[12\].u_fa/a_124_46# VPWR pfet_05v0 ad=0 pd=0 as=0 ps=0 w=0.66u l=0.5u
X546 bitslice\[12\].u_fa/a_512_496# a[12] VPWR VPWR pfet_05v0 ad=0 pd=0 as=0 ps=0 w=0.66u l=0.5u
X547 VGND b[12] bitslice\[12\].u_fa/a_1992_156# VGND nfet_05v0 ad=0 pd=0 as=0 ps=0 w=0.38u l=0.6u
X548 bitslice\[12\].u_fa/a_124_46# bitslice\[12\].u_fa/CI bitslice\[12\].u_fa/a_680_156# VGND nfet_05v0 ad=0 pd=0 as=91.2f ps=1.24u w=0.38u l=0.6u
X549 bitslice\[12\].u_fa/a_680_156# b[12] bitslice\[12\].u_fa/a_512_156# VGND nfet_05v0 ad=0 pd=0 as=0 ps=0 w=0.38u l=0.6u
X550 bitslice\[13\].u_fa/CI bitslice\[12\].u_fa/a_952_112# VPWR VPWR pfet_05v0 ad=0.5346p pd=3.31u as=0 ps=0 w=1.215u l=0.5u
X551 bitslice\[12\].u_fa/a_1992_156# a[12] VGND VGND nfet_05v0 ad=0 pd=0 as=0 ps=0 w=0.38u l=0.6u
X552 VGND a[12] bitslice\[12\].u_fa/a_1072_156# VGND nfet_05v0 ad=0 pd=0 as=0 ps=0 w=0.38u l=0.6u
X553 bitslice\[12\].u_fa/a_3048_156# b[12] bitslice\[12\].u_fa/a_952_112# VGND nfet_05v0 ad=0 pd=0 as=0 ps=0 w=0.38u l=0.6u
X554 VGND bitslice\[12\].u_fa/CI bitslice\[12\].u_fa/a_1072_156# VGND nfet_05v0 ad=0 pd=0 as=0 ps=0 w=0.38u l=0.6u
X555 bitslice\[12\].u_fa/a_2012_472# a[12] VPWR VPWR pfet_05v0 ad=0 pd=0 as=0 ps=0 w=0.7u l=0.5u
X556 bitslice\[18\].u_fa/a_1072_496# b[18] VPWR VPWR pfet_05v0 ad=0.7524p pd=4.92u as=0 ps=0 w=0.66u l=0.5u
X557 bitslice\[18\].u_fa/a_512_156# a[18] VGND VGND nfet_05v0 ad=91.2f pd=1.24u as=0 ps=0 w=0.38u l=0.6u
X558 bitslice\[18\].u_fa/a_124_46# bitslice\[18\].u_fa/CI bitslice\[18\].u_fa/a_680_496# VPWR pfet_05v0 ad=0.4092p pd=2.56u as=0.2244p ps=2u w=0.66u l=0.5u
X559 bitslice\[18\].u_fa/a_3028_472# b[18] bitslice\[18\].u_fa/a_952_112# VPWR pfet_05v0 ad=0.238p pd=2.08u as=0.434p ps=2.64u w=0.7u l=0.5u
X560 VPWR bitslice\[18\].u_fa/CI bitslice\[18\].u_fa/a_1072_496# VPWR pfet_05v0 ad=0 pd=0 as=0 ps=0 w=0.66u l=0.5u
X561 bitslice\[18\].u_fa/a_1072_156# b[18] VGND VGND nfet_05v0 ad=0.3952p pd=3.6u as=0 ps=0 w=0.38u l=0.6u
X562 bitslice\[18\].u_fa/a_680_496# b[18] bitslice\[18\].u_fa/a_512_496# VPWR pfet_05v0 ad=0 pd=0 as=0.2244p ps=2u w=0.66u l=0.5u
X563 bitslice\[18\].u_fa/a_1072_156# bitslice\[18\].u_fa/a_952_112# bitslice\[18\].u_fa/a_124_46# VGND nfet_05v0 ad=0 pd=0 as=0.1976p ps=1.8u w=0.38u l=0.6u
X564 VGND a[18] bitslice\[18\].u_fa/a_3048_156# VGND nfet_05v0 ad=0 pd=0 as=91.2f ps=1.24u w=0.38u l=0.6u
X565 VPWR a[18] bitslice\[18\].u_fa/a_1072_496# VPWR pfet_05v0 ad=0 pd=0 as=0 ps=0 w=0.66u l=0.5u
X566 bitslice\[18\].u_fa/a_952_112# bitslice\[18\].u_fa/CI bitslice\[18\].u_fa/a_1992_156# VGND nfet_05v0 ad=0.1976p pd=1.8u as=0.5896p ps=4.64u w=0.38u l=0.6u
X567 VPWR bitslice\[18\].u_fa/a_124_46# s[18] VPWR pfet_05v0 ad=0 pd=0 as=0.5346p ps=3.31u w=1.215u l=0.5u
X568 VPWR a[18] bitslice\[18\].u_fa/a_3028_472# VPWR pfet_05v0 ad=0 pd=0 as=0 ps=0 w=0.7u l=0.5u
X569 bitslice\[18\].u_fa/a_952_112# bitslice\[18\].u_fa/CI bitslice\[18\].u_fa/a_2012_472# VPWR pfet_05v0 ad=0 pd=0 as=1.05p ps=5.8u w=0.7u l=0.5u
X570 bitslice\[19\].u_fa/CI bitslice\[18\].u_fa/a_952_112# VGND VGND nfet_05v0 ad=0.3586p pd=2.51u as=0 ps=0 w=0.815u l=0.6u
X571 VPWR b[18] bitslice\[18\].u_fa/a_2012_472# VPWR pfet_05v0 ad=0 pd=0 as=0 ps=0 w=0.7u l=0.5u
X572 VGND bitslice\[18\].u_fa/a_124_46# s[18] VGND nfet_05v0 ad=0 pd=0 as=0.3124p ps=2.3u w=0.71u l=0.6u
X573 bitslice\[18\].u_fa/a_1072_496# bitslice\[18\].u_fa/a_952_112# bitslice\[18\].u_fa/a_124_46# VPWR pfet_05v0 ad=0 pd=0 as=0 ps=0 w=0.66u l=0.5u
X574 bitslice\[18\].u_fa/a_512_496# a[18] VPWR VPWR pfet_05v0 ad=0 pd=0 as=0 ps=0 w=0.66u l=0.5u
X575 VGND b[18] bitslice\[18\].u_fa/a_1992_156# VGND nfet_05v0 ad=0 pd=0 as=0 ps=0 w=0.38u l=0.6u
X576 bitslice\[18\].u_fa/a_124_46# bitslice\[18\].u_fa/CI bitslice\[18\].u_fa/a_680_156# VGND nfet_05v0 ad=0 pd=0 as=91.2f ps=1.24u w=0.38u l=0.6u
X577 bitslice\[18\].u_fa/a_680_156# b[18] bitslice\[18\].u_fa/a_512_156# VGND nfet_05v0 ad=0 pd=0 as=0 ps=0 w=0.38u l=0.6u
X578 bitslice\[19\].u_fa/CI bitslice\[18\].u_fa/a_952_112# VPWR VPWR pfet_05v0 ad=0.5346p pd=3.31u as=0 ps=0 w=1.215u l=0.5u
X579 bitslice\[18\].u_fa/a_1992_156# a[18] VGND VGND nfet_05v0 ad=0 pd=0 as=0 ps=0 w=0.38u l=0.6u
X580 VGND a[18] bitslice\[18\].u_fa/a_1072_156# VGND nfet_05v0 ad=0 pd=0 as=0 ps=0 w=0.38u l=0.6u
X581 bitslice\[18\].u_fa/a_3048_156# b[18] bitslice\[18\].u_fa/a_952_112# VGND nfet_05v0 ad=0 pd=0 as=0 ps=0 w=0.38u l=0.6u
X582 VGND bitslice\[18\].u_fa/CI bitslice\[18\].u_fa/a_1072_156# VGND nfet_05v0 ad=0 pd=0 as=0 ps=0 w=0.38u l=0.6u
X583 bitslice\[18\].u_fa/a_2012_472# a[18] VPWR VPWR pfet_05v0 ad=0 pd=0 as=0 ps=0 w=0.7u l=0.5u
X584 bitslice\[1\].u_fa/a_1072_496# b[1] VPWR VPWR pfet_05v0 ad=0.7524p pd=4.92u as=0 ps=0 w=0.66u l=0.5u
X585 bitslice\[1\].u_fa/a_512_156# a[1] VGND VGND nfet_05v0 ad=91.2f pd=1.24u as=0 ps=0 w=0.38u l=0.6u
X586 bitslice\[1\].u_fa/a_124_46# bitslice\[1\].u_fa/CI bitslice\[1\].u_fa/a_680_496# VPWR pfet_05v0 ad=0.4092p pd=2.56u as=0.2244p ps=2u w=0.66u l=0.5u
X587 bitslice\[1\].u_fa/a_3028_472# b[1] bitslice\[1\].u_fa/a_952_112# VPWR pfet_05v0 ad=0.238p pd=2.08u as=0.434p ps=2.64u w=0.7u l=0.5u
X588 VPWR bitslice\[1\].u_fa/CI bitslice\[1\].u_fa/a_1072_496# VPWR pfet_05v0 ad=0 pd=0 as=0 ps=0 w=0.66u l=0.5u
X589 bitslice\[1\].u_fa/a_1072_156# b[1] VGND VGND nfet_05v0 ad=0.3952p pd=3.6u as=0 ps=0 w=0.38u l=0.6u
X590 bitslice\[1\].u_fa/a_680_496# b[1] bitslice\[1\].u_fa/a_512_496# VPWR pfet_05v0 ad=0 pd=0 as=0.2244p ps=2u w=0.66u l=0.5u
X591 bitslice\[1\].u_fa/a_1072_156# bitslice\[1\].u_fa/a_952_112# bitslice\[1\].u_fa/a_124_46# VGND nfet_05v0 ad=0 pd=0 as=0.1976p ps=1.8u w=0.38u l=0.6u
X592 VGND a[1] bitslice\[1\].u_fa/a_3048_156# VGND nfet_05v0 ad=0 pd=0 as=91.2f ps=1.24u w=0.38u l=0.6u
X593 VPWR a[1] bitslice\[1\].u_fa/a_1072_496# VPWR pfet_05v0 ad=0 pd=0 as=0 ps=0 w=0.66u l=0.5u
X594 bitslice\[1\].u_fa/a_952_112# bitslice\[1\].u_fa/CI bitslice\[1\].u_fa/a_1992_156# VGND nfet_05v0 ad=0.1976p pd=1.8u as=0.5896p ps=4.64u w=0.38u l=0.6u
X595 VPWR bitslice\[1\].u_fa/a_124_46# s[1] VPWR pfet_05v0 ad=0 pd=0 as=0.5346p ps=3.31u w=1.215u l=0.5u
X596 VPWR a[1] bitslice\[1\].u_fa/a_3028_472# VPWR pfet_05v0 ad=0 pd=0 as=0 ps=0 w=0.7u l=0.5u
X597 bitslice\[1\].u_fa/a_952_112# bitslice\[1\].u_fa/CI bitslice\[1\].u_fa/a_2012_472# VPWR pfet_05v0 ad=0 pd=0 as=1.05p ps=5.8u w=0.7u l=0.5u
X598 bitslice\[2\].u_fa/CI bitslice\[1\].u_fa/a_952_112# VGND VGND nfet_05v0 ad=0.3586p pd=2.51u as=0 ps=0 w=0.815u l=0.6u
X599 VPWR b[1] bitslice\[1\].u_fa/a_2012_472# VPWR pfet_05v0 ad=0 pd=0 as=0 ps=0 w=0.7u l=0.5u
X600 VGND bitslice\[1\].u_fa/a_124_46# s[1] VGND nfet_05v0 ad=0 pd=0 as=0.3124p ps=2.3u w=0.71u l=0.6u
X601 bitslice\[1\].u_fa/a_1072_496# bitslice\[1\].u_fa/a_952_112# bitslice\[1\].u_fa/a_124_46# VPWR pfet_05v0 ad=0 pd=0 as=0 ps=0 w=0.66u l=0.5u
X602 bitslice\[1\].u_fa/a_512_496# a[1] VPWR VPWR pfet_05v0 ad=0 pd=0 as=0 ps=0 w=0.66u l=0.5u
X603 VGND b[1] bitslice\[1\].u_fa/a_1992_156# VGND nfet_05v0 ad=0 pd=0 as=0 ps=0 w=0.38u l=0.6u
X604 bitslice\[1\].u_fa/a_124_46# bitslice\[1\].u_fa/CI bitslice\[1\].u_fa/a_680_156# VGND nfet_05v0 ad=0 pd=0 as=91.2f ps=1.24u w=0.38u l=0.6u
X605 bitslice\[1\].u_fa/a_680_156# b[1] bitslice\[1\].u_fa/a_512_156# VGND nfet_05v0 ad=0 pd=0 as=0 ps=0 w=0.38u l=0.6u
X606 bitslice\[2\].u_fa/CI bitslice\[1\].u_fa/a_952_112# VPWR VPWR pfet_05v0 ad=0.5346p pd=3.31u as=0 ps=0 w=1.215u l=0.5u
X607 bitslice\[1\].u_fa/a_1992_156# a[1] VGND VGND nfet_05v0 ad=0 pd=0 as=0 ps=0 w=0.38u l=0.6u
X608 VGND a[1] bitslice\[1\].u_fa/a_1072_156# VGND nfet_05v0 ad=0 pd=0 as=0 ps=0 w=0.38u l=0.6u
X609 bitslice\[1\].u_fa/a_3048_156# b[1] bitslice\[1\].u_fa/a_952_112# VGND nfet_05v0 ad=0 pd=0 as=0 ps=0 w=0.38u l=0.6u
X610 VGND bitslice\[1\].u_fa/CI bitslice\[1\].u_fa/a_1072_156# VGND nfet_05v0 ad=0 pd=0 as=0 ps=0 w=0.38u l=0.6u
X611 bitslice\[1\].u_fa/a_2012_472# a[1] VPWR VPWR pfet_05v0 ad=0 pd=0 as=0 ps=0 w=0.7u l=0.5u
C0 a[14] bitslice\[14\].u_fa/a_680_156# 0
C1 bitslice\[11\].u_fa/CI bitslice\[11\].u_fa/a_1072_156# 0.61608f
C2 bitslice\[13\].u_fa/a_1072_496# bitslice\[13\].u_fa/a_512_496# 0
C3 bitslice\[0\].u_fa/a_124_46# bitslice\[0\].u_fa/a_680_496# 0.00655f
C4 bitslice\[8\].u_fa/a_512_496# bitslice\[8\].u_fa/a_124_46# 0.00639f
C5 bitslice\[7\].u_fa/a_3028_472# bitslice\[7\].u_fa/a_952_112# 0.00197f
C6 bitslice\[7\].u_fa/a_1072_496# bitslice\[7\].u_fa/a_680_496# 0
C7 VPWR bitslice\[7\].u_fa/a_512_156# 0
C8 bitslice\[12\].u_fa/a_124_46# b[13] 0
C9 a[10] s[11] 0
C10 a[20] a[19] 0.86295f
C11 VPWR a[15] 0.76087f
C12 a[8] bitslice\[8\].u_fa/a_512_496# 0
C13 VPWR bitslice\[19\].u_fa/a_124_46# 0.46957f
C14 s[20] a[21] 0.20011f
C15 u_msb_x3/a_1524_472# u_msb_x3/A3 0
C16 a[1] bitslice\[1\].u_fa/a_124_46# 0.60604f
C17 s[1] bitslice\[1\].u_fa/a_512_496# 0
C18 b[19] bitslice\[19\].u_fa/a_124_46# 0.05484f
C19 a[12] s[13] 0
C20 s[12] a[13] 0.20011f
C21 VPWR bitslice\[17\].u_fa/a_124_46# 0.46957f
C22 s[16] bitslice\[16\].u_fa/a_124_46# 0.26234f
C23 b[16] bitslice\[16\].u_fa/a_952_112# 0.77989f
C24 FILLER_21_2/a_124_375# FILLER_21_2/a_572_375# 0.01222f
C25 bitslice\[7\].u_fa/a_1072_496# a[7] 0.02208f
C26 s[12] b[12] 0.00338f
C27 a[20] FILLER_21_2/a_36_472# 0
C28 bitslice\[18\].u_fa/a_1072_496# bitslice\[18\].u_fa/a_124_46# 0.0139f
C29 a[21] VPWR 1.05455f
C30 bitslice\[2\].u_fa/a_680_496# bitslice\[2\].u_fa/a_1072_496# 0
C31 b[17] b[16] 0.83145f
C32 cin bitslice\[0\].u_fa/a_3048_156# 0
C33 b[9] bitslice\[8\].u_fa/CI 0.00387f
C34 VPWR bitslice\[13\].u_fa/a_680_156# 0
C35 b[19] a[21] 0.00285f
C36 s[3] s[2] 0.00769f
C37 VPWR a[18] 0.67821f
C38 s[19] bitslice\[19\].u_fa/a_952_112# 0.00139f
C39 bitslice\[7\].u_fa/CI bitslice\[7\].u_fa/a_1072_496# 0.00463f
C40 b[19] a[18] 0
C41 bitslice\[4\].u_fa/CI bitslice\[4\].u_fa/a_3028_472# 0.00135f
C42 bitslice\[9\].u_fa/CO bitslice\[10\].u_fa/a_1992_156# 0.70111f
C43 a[2] b[2] 0.46601f
C44 b[5] bitslice\[6\].u_fa/CI 0.08552f
C45 s[4] s[3] 0.00743f
C46 bitslice\[11\].u_fa/a_952_112# bitslice\[13\].u_fa/CI 0
C47 bitslice\[12\].u_fa/a_1072_496# bitslice\[12\].u_fa/a_680_496# 0
C48 u_msb_x3/a_56_524# VPWR 0.30967f
C49 bitslice\[5\].u_fa/a_680_496# VPWR 0.00283f
C50 bitslice\[1\].u_fa/a_952_112# bitslice\[2\].u_fa/CI 0.1229f
C51 bitslice\[18\].u_fa/a_1072_496# bitslice\[18\].u_fa/a_512_496# 0
C52 VPWR bitslice\[15\].u_fa/a_952_112# 0.59588f
C53 a[11] s[12] 0
C54 FILLER_21_2/a_124_375# bitslice\[19\].u_fa/a_124_46# 0
C55 a[16] b[16] 0.46601f
C56 a[4] s[4] 0.17692f
C57 s[8] bitslice\[8\].u_fa/a_124_46# 0.26234f
C58 bitslice\[15\].u_fa/CI bitslice\[15\].u_fa/a_3028_472# 0.00336f
C59 b[0] s[0] 0.00338f
C60 bitslice\[11\].u_fa/CI a[10] 0.01041f
C61 bitslice\[2\].u_fa/a_512_156# VPWR 0
C62 bitslice\[6\].u_fa/a_952_112# bitslice\[6\].u_fa/a_1072_496# 0.64312f
C63 VPWR a[17] 0.76087f
C64 bitslice\[11\].u_fa/a_3028_472# bitslice\[11\].u_fa/a_2012_472# 0
C65 a[8] s[8] 0.17692f
C66 bitslice\[19\].u_fa/a_680_496# bitslice\[19\].u_fa/a_1072_496# 0
C67 bitslice\[3\].u_fa/a_952_112# b[2] 0.00248f
C68 bitslice\[4\].u_fa/CI bitslice\[4\].u_fa/a_1072_496# 0.00434f
C69 VPWR b[7] 1.90176f
C70 bitslice\[13\].u_fa/a_2012_472# b[13] 0.02435f
C71 a[21] FILLER_21_2/a_124_375# 0.01546f
C72 a[15] s[15] 0.1788f
C73 bitslice\[9\].u_fa/a_3028_472# b[9] 0.00428f
C74 b[1] bitslice\[1\].u_fa/a_1992_156# 0.03179f
C75 s[5] bitslice\[5\].u_fa/a_512_496# 0
C76 bitslice\[5\].u_fa/a_3028_472# bitslice\[5\].u_fa/a_952_112# 0.00197f
C77 a[10] bitslice\[10\].u_fa/a_952_112# 0.17729f
C78 b[10] bitslice\[10\].u_fa/a_2012_472# 0.02435f
C79 bitslice\[6\].u_fa/CI bitslice\[6\].u_fa/a_3028_472# 0.00135f
C80 bitslice\[14\].u_fa/a_3028_472# VPWR 0.00593f
C81 bitslice\[13\].u_fa/a_952_112# bitslice\[13\].u_fa/a_124_46# 0.01486f
C82 s[21] u_msb_x3/a_2215_68# 0.00999f
C83 a[14] s[13] 0.19959f
C84 bitslice\[14\].u_fa/a_952_112# s[14] 0.00117f
C85 bitslice\[13\].u_fa/a_1072_156# s[13] 0
C86 bitslice\[4\].u_fa/a_1992_156# bitslice\[4\].u_fa/a_1072_156# 0.00753f
C87 VPWR bitslice\[19\].u_fa/CI 0.93367f
C88 bitslice\[17\].u_fa/CI bitslice\[19\].u_fa/a_952_112# 0
C89 b[18] bitslice\[19\].u_fa/a_952_112# 0.00248f
C90 a[20] FILLER_21_2/a_572_375# 0
C91 bitslice\[0\].u_fa/a_124_46# bitslice\[0\].u_fa/a_512_156# 0.00257f
C92 bitslice\[20\].u_fa/CI bitslice\[19\].u_fa/a_3048_156# 0.00141f
C93 b[1] b[0] 0.83145f
C94 bitslice\[12\].u_fa/a_124_46# a[13] 0.00783f
C95 bitslice\[1\].u_fa/a_512_496# bitslice\[1\].u_fa/a_124_46# 0.00639f
C96 b[19] bitslice\[19\].u_fa/CI 0.41328f
C97 bitslice\[17\].u_fa/a_952_112# b[18] 0
C98 bitslice\[6\].u_fa/a_952_112# bitslice\[6\].u_fa/CI 2.42979f
C99 bitslice\[17\].u_fa/CI bitslice\[17\].u_fa/a_952_112# 2.44171f
C100 bitslice\[20\].u_fa/a_1072_496# bitslice\[20\].u_fa/a_680_496# 0
C101 bitslice\[8\].u_fa/a_3048_156# bitslice\[9\].u_fa/CI 0
C102 bitslice\[12\].u_fa/CI bitslice\[12\].u_fa/a_2012_472# 0.00394f
C103 b[12] bitslice\[12\].u_fa/a_124_46# 0.05484f
C104 b[6] bitslice\[6\].u_fa/a_1072_496# 0.02505f
C105 bitslice\[12\].u_fa/CI b[11] 0.08552f
C106 bitslice\[3\].u_fa/a_3028_472# bitslice\[3\].u_fa/a_2012_472# 0
C107 bitslice\[20\].u_fa/a_124_46# bitslice\[20\].u_fa/CI 0.27486f
C108 bitslice\[8\].u_fa/a_2012_472# bitslice\[8\].u_fa/CI 0.00394f
C109 bitslice\[15\].u_fa/a_2012_472# bitslice\[15\].u_fa/a_1072_496# 0.00406f
C110 bitslice\[14\].u_fa/a_952_112# bitslice\[14\].u_fa/a_3048_156# 0.00316f
C111 bitslice\[2\].u_fa/a_1072_156# VPWR 0.01572f
C112 bitslice\[8\].u_fa/a_952_112# b[7] 0.0025f
C113 b[1] bitslice\[1\].u_fa/a_2012_472# 0.02435f
C114 a[4] bitslice\[4\].u_fa/a_680_156# 0
C115 VPWR bitslice\[8\].u_fa/a_680_156# 0
C116 b[20] FILLER_21_2/a_484_472# 0
C117 a[20] b[21] 0.00129f
C118 bitslice\[18\].u_fa/a_512_496# bitslice\[18\].u_fa/a_124_46# 0.00639f
C119 s[15] bitslice\[15\].u_fa/a_952_112# 0.00139f
C120 VPWR bitslice\[9\].u_fa/a_512_156# 0
C121 a[18] s[18] 0.17692f
C122 bitslice\[3\].u_fa/a_952_112# bitslice\[3\].u_fa/a_3028_472# 0.00197f
C123 bitslice\[4\].u_fa/a_124_46# a[5] 0.00783f
C124 bitslice\[10\].u_fa/a_680_496# s[10] 0
C125 bitslice\[14\].u_fa/a_1072_496# s[14] 0.00165f
C126 bitslice\[15\].u_fa/CI b[15] 0.41328f
C127 VPWR bitslice\[14\].u_fa/CI 0.7208f
C128 bitslice\[3\].u_fa/CI b[4] 0
C129 b[11] bitslice\[11\].u_fa/a_124_46# 0.05484f
C130 bitslice\[2\].u_fa/a_512_496# bitslice\[2\].u_fa/a_124_46# 0.00639f
C131 a[11] s[11] 0.1788f
C132 bitslice\[5\].u_fa/a_2012_472# bitslice\[5\].u_fa/CI 0.00772f
C133 bitslice\[8\].u_fa/CI bitslice\[7\].u_fa/a_952_112# 0.1229f
C134 b[17] bitslice\[17\].u_fa/a_2012_472# 0.02435f
C135 bitslice\[6\].u_fa/a_952_112# bitslice\[7\].u_fa/a_952_112# 0.02943f
C136 a[20] bitslice\[19\].u_fa/a_124_46# 0.00806f
C137 bitslice\[20\].u_fa/CI b[20] 0.34555f
C138 bitslice\[14\].u_fa/a_3028_472# bitslice\[14\].u_fa/a_2012_472# 0
C139 VPWR s[2] 0.34826f
C140 s[8] s[7] 0.00743f
C141 a[11] bitslice\[12\].u_fa/a_124_46# 0
C142 bitslice\[0\].u_fa/a_1992_156# b[0] 0.03179f
C143 u_msb_x3/a_2215_68# VPWR 0.00168f
C144 VPWR bitslice\[6\].u_fa/a_512_496# 0.00292f
C145 bitslice\[2\].u_fa/a_952_112# a[3] 0
C146 b[5] bitslice\[5\].u_fa/a_1072_156# 0.0302f
C147 s[5] bitslice\[5\].u_fa/a_680_156# 0
C148 b[5] bitslice\[5\].u_fa/a_952_112# 0.77779f
C149 b[12] bitslice\[11\].u_fa/CI 0
C150 VPWR s[4] 0.34826f
C151 b[4] bitslice\[4\].u_fa/a_124_46# 0.05484f
C152 bitslice\[13\].u_fa/a_1072_496# s[13] 0
C153 bitslice\[20\].u_fa/CI bitslice\[19\].u_fa/a_1992_156# 0.001f
C154 bitslice\[6\].u_fa/CI b[6] 0.34555f
C155 s[18] a[17] 0
C156 bitslice\[14\].u_fa/a_1072_156# bitslice\[14\].u_fa/CI 0.61603f
C157 bitslice\[19\].u_fa/a_3048_156# bitslice\[18\].u_fa/CI 0
C158 a[20] a[21] 0.03756f
C159 VPWR bitslice\[7\].u_fa/a_512_496# 0.00292f
C160 a[20] bitslice\[20\].u_fa/a_1992_156# 0.03766f
C161 VPWR bitslice\[15\].u_fa/a_1072_156# 0.01572f
C162 a[3] b[3] 0.46296f
C163 a[19] bitslice\[19\].u_fa/a_952_112# 0.17786f
C164 VPWR bitslice\[1\].u_fa/a_512_156# 0
C165 VPWR bitslice\[10\].u_fa/a_512_156# 0
C166 s[17] s[16] 0.00769f
C167 a[9] bitslice\[9\].u_fa/a_680_496# 0.00136f
C168 bitslice\[17\].u_fa/a_2012_472# bitslice\[17\].u_fa/a_3028_472# 0
C169 bitslice\[13\].u_fa/a_952_112# b[13] 0.77889f
C170 bitslice\[5\].u_fa/a_512_496# bitslice\[5\].u_fa/a_124_46# 0.00639f
C171 bitslice\[10\].u_fa/a_2012_472# bitslice\[10\].u_fa/a_1072_496# 0.00406f
C172 bitslice\[10\].u_fa/a_1072_156# bitslice\[10\].u_fa/a_124_46# 0.0288f
C173 b[4] a[5] 0
C174 bitslice\[6\].u_fa/a_952_112# a[6] 0.17729f
C175 bitslice\[11\].u_fa/a_2012_472# bitslice\[11\].u_fa/CI 0.00772f
C176 b[12] bitslice\[12\].u_fa/a_1072_156# 0.0302f
C177 s[12] bitslice\[12\].u_fa/a_680_156# 0
C178 bitslice\[13\].u_fa/a_2012_472# a[13] 0.01751f
C179 a[20] u_msb_x3/a_56_524# 0
C180 bitslice\[4\].u_fa/a_3048_156# bitslice\[5\].u_fa/CI 0
C181 bitslice\[19\].u_fa/a_1072_156# bitslice\[19\].u_fa/a_1992_156# 0.00753f
C182 bitslice\[2\].u_fa/a_1072_496# s[2] 0.00165f
C183 a[0] bitslice\[0\].u_fa/a_124_46# 0.60698f
C184 bitslice\[14\].u_fa/CI bitslice\[14\].u_fa/a_2012_472# 0.00394f
C185 b[6] bitslice\[7\].u_fa/a_952_112# 0.00248f
C186 VPWR bitslice\[18\].u_fa/a_1072_156# 0.01572f
C187 a[11] bitslice\[11\].u_fa/CI 0.22669f
C188 b[16] VPWR 1.90361f
C189 VPWR bitslice\[9\].u_fa/CO 0.73255f
C190 bitslice\[3\].u_fa/a_1072_156# b[3] 0.0302f
C191 bitslice\[3\].u_fa/a_952_112# bitslice\[4\].u_fa/CI 0.1229f
C192 bitslice\[17\].u_fa/a_3048_156# bitslice\[19\].u_fa/CI 0
C193 VPWR bitslice\[11\].u_fa/a_1072_496# 0.28074f
C194 bitslice\[4\].u_fa/CI bitslice\[4\].u_fa/a_952_112# 2.42849f
C195 bitslice\[18\].u_fa/CI bitslice\[17\].u_fa/a_1992_156# 0.001f
C196 bitslice\[6\].u_fa/a_124_46# bitslice\[6\].u_fa/a_952_112# 0.01486f
C197 bitslice\[16\].u_fa/a_512_496# bitslice\[16\].u_fa/a_124_46# 0.00639f
C198 s[8] a[9] 0.20011f
C199 a[4] bitslice\[5\].u_fa/CI 0.01201f
C200 bitslice\[0\].u_fa/a_952_112# bitslice\[1\].u_fa/a_952_112# 0.02943f
C201 b[7] b[8] 0.1159f
C202 b[20] bitslice\[18\].u_fa/CI 0
C203 bitslice\[14\].u_fa/CI bitslice\[13\].u_fa/CI 0.12494f
C204 s[17] bitslice\[17\].u_fa/a_1072_496# 0
C205 bitslice\[19\].u_fa/a_2012_472# bitslice\[19\].u_fa/a_952_112# 0.7796f
C206 b[14] bitslice\[16\].u_fa/CI 0.00259f
C207 b[17] bitslice\[16\].u_fa/a_952_112# 0.00226f
C208 bitslice\[15\].u_fa/a_680_156# bitslice\[15\].u_fa/a_124_46# 0.00316f
C209 cin bitslice\[1\].u_fa/a_1992_156# 0
C210 VPWR bitslice\[4\].u_fa/a_680_156# 0
C211 a[11] bitslice\[10\].u_fa/a_952_112# 0
C212 bitslice\[20\].u_fa/a_124_46# bitslice\[20\].u_fa/a_1072_496# 0.0139f
C213 bitslice\[6\].u_fa/a_952_112# bitslice\[5\].u_fa/a_952_112# 0.03505f
C214 a[10] b[10] 0.46601f
C215 a[6] b[6] 0.46601f
C216 s[0] bitslice\[0\].u_fa/a_1072_496# 0.00165f
C217 bitslice\[11\].u_fa/a_680_496# bitslice\[11\].u_fa/a_124_46# 0.00655f
C218 VPWR bitslice\[9\].u_fa/a_952_112# 0.59588f
C219 s[16] bitslice\[16\].u_fa/a_680_156# 0
C220 bitslice\[14\].u_fa/a_952_112# bitslice\[14\].u_fa/a_124_46# 0.01486f
C221 bitslice\[7\].u_fa/a_512_156# bitslice\[7\].u_fa/a_124_46# 0.00257f
C222 bitslice\[6\].u_fa/CI a[5] 0.01364f
C223 bitslice\[13\].u_fa/a_512_496# s[13] 0
C224 cin b[0] 0.30044f
C225 bitslice\[8\].u_fa/a_952_112# bitslice\[9\].u_fa/CO 0.00385f
C226 s[15] bitslice\[15\].u_fa/a_1072_156# 0
C227 a[20] bitslice\[19\].u_fa/CI 0.00171f
C228 b[15] bitslice\[15\].u_fa/a_1992_156# 0.03179f
C229 VPWR bitslice\[19\].u_fa/a_1072_496# 0.28074f
C230 bitslice\[12\].u_fa/CI bitslice\[13\].u_fa/a_3028_472# 0
C231 bitslice\[3\].u_fa/a_512_156# s[3] 0.00108f
C232 b[19] bitslice\[19\].u_fa/a_1072_496# 0.02505f
C233 a[1] bitslice\[1\].u_fa/a_680_496# 0.00136f
C234 bitslice\[5\].u_fa/a_680_156# bitslice\[5\].u_fa/a_124_46# 0.00316f
C235 a[16] bitslice\[16\].u_fa/a_952_112# 0.17729f
C236 s[16] bitslice\[16\].u_fa/a_680_496# 0
C237 b[16] bitslice\[16\].u_fa/a_1072_496# 0.02505f
C238 a[12] s[12] 0.17692f
C239 bitslice\[6\].u_fa/a_124_46# b[6] 0.05484f
C240 cin bitslice\[1\].u_fa/a_2012_472# 0
C241 b[20] bitslice\[20\].u_fa/a_1072_496# 0.02505f
C242 bitslice\[13\].u_fa/a_3048_156# bitslice\[13\].u_fa/a_952_112# 0.00316f
C243 s[8] a[7] 0
C244 bitslice\[11\].u_fa/a_124_46# bitslice\[11\].u_fa/a_512_156# 0.00257f
C245 b[17] a[16] 0
C246 VPWR bitslice\[18\].u_fa/a_1072_496# 0.28074f
C247 b[17] bitslice\[17\].u_fa/a_3028_472# 0.00428f
C248 bitslice\[6\].u_fa/CI b[4] 0.00259f
C249 cin bitslice\[0\].u_fa/a_2012_472# 0.00607f
C250 bitslice\[4\].u_fa/a_3028_472# bitslice\[4\].u_fa/a_2012_472# 0
C251 a[15] bitslice\[15\].u_fa/a_512_496# 0.002f
C252 bitslice\[4\].u_fa/CI bitslice\[4\].u_fa/a_1072_156# 0.61603f
C253 s[9] b[9] 0.00448f
C254 b[6] bitslice\[5\].u_fa/a_952_112# 0.00242f
C255 bitslice\[12\].u_fa/a_680_156# bitslice\[12\].u_fa/a_124_46# 0.00316f
C256 bitslice\[11\].u_fa/a_952_112# bitslice\[11\].u_fa/a_1072_156# 0.00934f
C257 bitslice\[14\].u_fa/a_1072_496# bitslice\[14\].u_fa/a_124_46# 0.0139f
C258 bitslice\[8\].u_fa/a_952_112# bitslice\[9\].u_fa/a_952_112# 0.02943f
C259 b[20] u_msb_x3/a_728_93# 0.04568f
C260 bitslice\[6\].u_fa/CI bitslice\[6\].u_fa/a_1072_496# 0.00434f
C261 s[17] bitslice\[17\].u_fa/a_680_496# 0
C262 u_msb_x3/A3 FILLER_21_2/a_484_472# 0
C263 VPWR bitslice\[2\].u_fa/CI 0.72367f
C264 bitslice\[13\].u_fa/a_952_112# a[13] 0.17786f
C265 b[2] a[3] 0
C266 bitslice\[13\].u_fa/a_952_112# b[12] 0.00248f
C267 s[17] bitslice\[17\].u_fa/a_1072_156# 0
C268 a[4] bitslice\[4\].u_fa/a_680_496# 0
C269 b[21] bitslice\[19\].u_fa/a_952_112# 0
C270 a[18] bitslice\[18\].u_fa/a_512_156# 0
C271 b[18] bitslice\[18\].u_fa/a_1992_156# 0.03179f
C272 bitslice\[16\].u_fa/CI bitslice\[16\].u_fa/a_2012_472# 0.00394f
C273 a[0] s[1] 0
C274 bitslice\[20\].u_fa/CI u_msb_x3/A3 0.04682f
C275 VPWR bitslice\[5\].u_fa/CI 0.9263f
C276 a[15] bitslice\[15\].u_fa/a_680_496# 0.00136f
C277 bitslice\[4\].u_fa/a_512_156# bitslice\[4\].u_fa/a_124_46# 0.00257f
C278 bitslice\[4\].u_fa/a_2012_472# bitslice\[4\].u_fa/a_1072_496# 0.00406f
C279 bitslice\[13\].u_fa/a_680_156# bitslice\[13\].u_fa/a_124_46# 0.00316f
C280 b[7] bitslice\[7\].u_fa/a_124_46# 0.05484f
C281 a[6] a[5] 0.86295f
C282 bitslice\[1\].u_fa/CI bitslice\[2\].u_fa/CI 0.0903f
C283 bitslice\[17\].u_fa/a_2012_472# VPWR 0.29058f
C284 bitslice\[19\].u_fa/a_952_112# bitslice\[19\].u_fa/a_124_46# 0.01486f
C285 a[1] bitslice\[1\].u_fa/a_1992_156# 0.03757f
C286 bitslice\[9\].u_fa/a_1072_156# b[9] 0.0302f
C287 s[21] u_msb_x3/a_952_93# 0
C288 b[5] bitslice\[5\].u_fa/a_1072_496# 0.02505f
C289 a[10] bitslice\[10\].u_fa/a_1072_496# 0.01952f
C290 VPWR bitslice\[9\].u_fa/CI 0.95052f
C291 bitslice\[17\].u_fa/a_952_112# bitslice\[17\].u_fa/a_124_46# 0.01486f
C292 bitslice\[2\].u_fa/a_1072_496# bitslice\[2\].u_fa/CI 0.00434f
C293 a[2] bitslice\[2\].u_fa/a_124_46# 0.60698f
C294 bitslice\[6\].u_fa/a_124_46# a[5] 0
C295 bitslice\[9\].u_fa/CO b[8] 0.00215f
C296 bitslice\[17\].u_fa/a_1072_496# bitslice\[17\].u_fa/CI 0.00463f
C297 a[21] bitslice\[19\].u_fa/a_952_112# 0.00267f
C298 VPWR bitslice\[18\].u_fa/a_124_46# 0.46952f
C299 bitslice\[15\].u_fa/a_3028_472# bitslice\[15\].u_fa/a_2012_472# 0
C300 s[6] s[7] 0.00831f
C301 bitslice\[7\].u_fa/CI bitslice\[7\].u_fa/a_3048_156# 0
C302 a[12] s[11] 0.19959f
C303 a[18] bitslice\[19\].u_fa/a_952_112# 0
C304 b[19] bitslice\[18\].u_fa/a_124_46# 0
C305 VPWR bitslice\[1\].u_fa/a_952_112# 0.59588f
C306 a[1] b[0] 0
C307 VPWR bitslice\[12\].u_fa/a_512_156# 0
C308 bitslice\[17\].u_fa/CI bitslice\[19\].u_fa/a_3028_472# 0
C309 bitslice\[1\].u_fa/a_1072_496# bitslice\[1\].u_fa/a_952_112# 0.64312f
C310 bitslice\[10\].u_fa/a_952_112# bitslice\[10\].u_fa/a_124_46# 0.01486f
C311 bitslice\[11\].u_fa/a_952_112# a[10] 0
C312 bitslice\[6\].u_fa/a_952_112# bitslice\[6\].u_fa/a_1072_156# 0.00934f
C313 bitslice\[20\].u_fa/a_3028_472# bitslice\[20\].u_fa/a_2012_472# 0
C314 s[9] s[10] 0.00743f
C315 a[12] bitslice\[12\].u_fa/a_124_46# 0.60698f
C316 s[12] bitslice\[12\].u_fa/a_512_496# 0.00137f
C317 a[6] bitslice\[6\].u_fa/a_1072_496# 0.01952f
C318 bitslice\[9\].u_fa/a_1072_496# bitslice\[9\].u_fa/a_952_112# 0.64312f
C319 bitslice\[8\].u_fa/CI bitslice\[8\].u_fa/a_1072_496# 0.00434f
C320 a[5] bitslice\[5\].u_fa/a_952_112# 0.17786f
C321 bitslice\[5\].u_fa/a_1072_156# a[5] 0.03679f
C322 s[1] bitslice\[1\].u_fa/a_1072_156# 0
C323 bitslice\[1\].u_fa/a_3048_156# bitslice\[2\].u_fa/CI 0.00141f
C324 a[1] bitslice\[1\].u_fa/a_2012_472# 0.01751f
C325 bitslice\[18\].u_fa/a_1072_496# s[18] 0.00165f
C326 a[4] s[3] 0.19959f
C327 VPWR bitslice\[3\].u_fa/a_512_156# 0
C328 bitslice\[6\].u_fa/CI bitslice\[7\].u_fa/a_952_112# 0.00139f
C329 a[11] b[10] 0
C330 VPWR bitslice\[18\].u_fa/a_512_496# 0.00292f
C331 bitslice\[8\].u_fa/a_3028_472# bitslice\[9\].u_fa/CO 0
C332 bitslice\[18\].u_fa/CI u_msb_x3/A3 0
C333 b[8] bitslice\[9\].u_fa/a_952_112# 0
C334 bitslice\[1\].u_fa/CI bitslice\[1\].u_fa/a_952_112# 2.44171f
C335 a[14] bitslice\[14\].u_fa/a_952_112# 0.17729f
C336 bitslice\[14\].u_fa/a_512_496# VPWR 0.00292f
C337 bitslice\[8\].u_fa/a_952_112# bitslice\[9\].u_fa/CI 0.12282f
C338 bitslice\[15\].u_fa/CI a[15] 0.22669f
C339 bitslice\[20\].u_fa/a_680_156# a[21] 0
C340 bitslice\[6\].u_fa/a_124_46# bitslice\[6\].u_fa/a_1072_496# 0.0139f
C341 bitslice\[2\].u_fa/a_512_496# s[2] 0.00137f
C342 bitslice\[17\].u_fa/a_952_112# a[17] 0.17786f
C343 s[7] bitslice\[7\].u_fa/a_512_156# 0.00108f
C344 b[4] bitslice\[5\].u_fa/a_952_112# 0.00248f
C345 s[6] bitslice\[6\].u_fa/a_680_496# 0
C346 VPWR bitslice\[4\].u_fa/a_680_496# 0.00283f
C347 VPWR bitslice\[16\].u_fa/a_952_112# 0.59588f
C348 VPWR bitslice\[20\].u_fa/a_3028_472# 0.00593f
C349 a[12] bitslice\[11\].u_fa/CI 0.00171f
C350 b[6] bitslice\[6\].u_fa/a_1072_156# 0.0302f
C351 bitslice\[6\].u_fa/CI a[6] 0.22372f
C352 s[6] bitslice\[6\].u_fa/a_680_156# 0
C353 bitslice\[15\].u_fa/a_124_46# bitslice\[15\].u_fa/a_1072_496# 0.0139f
C354 a[0] bitslice\[1\].u_fa/a_124_46# 0
C355 bitslice\[9\].u_fa/a_124_46# bitslice\[9\].u_fa/a_680_496# 0.00655f
C356 a[2] bitslice\[2\].u_fa/a_680_496# 0
C357 bitslice\[19\].u_fa/a_680_496# VPWR 0.00283f
C358 b[17] VPWR 1.9017f
C359 bitslice\[7\].u_fa/a_512_496# bitslice\[7\].u_fa/a_124_46# 0.00639f
C360 bitslice\[14\].u_fa/a_1072_496# a[14] 0.01952f
C361 VPWR bitslice\[7\].u_fa/a_2012_472# 0.29058f
C362 u_msb_x3/a_1336_472# FILLER_21_2/a_572_375# 0
C363 cin bitslice\[0\].u_fa/a_1072_496# 0.00434f
C364 bitslice\[17\].u_fa/a_1072_156# bitslice\[17\].u_fa/CI 0.61608f
C365 bitslice\[5\].u_fa/a_2012_472# VPWR 0.29058f
C366 b[15] bitslice\[15\].u_fa/a_2012_472# 0.02435f
C367 bitslice\[8\].u_fa/a_952_112# bitslice\[8\].u_fa/a_3048_156# 0.00316f
C368 bitslice\[18\].u_fa/a_952_112# u_msb_x3/A3 0
C369 bitslice\[20\].u_fa/a_1072_496# u_msb_x3/A3 0.00194f
C370 bitslice\[8\].u_fa/a_680_156# bitslice\[8\].u_fa/a_124_46# 0.00316f
C371 u_msb_x3/a_1524_472# u_msb_x3/a_728_93# 0.00714f
C372 bitslice\[19\].u_fa/CI bitslice\[19\].u_fa/a_952_112# 2.44171f
C373 bitslice\[1\].u_fa/a_3048_156# bitslice\[1\].u_fa/a_952_112# 0.00316f
C374 bitslice\[16\].u_fa/a_3048_156# bitslice\[16\].u_fa/a_952_112# 0.00316f
C375 bitslice\[4\].u_fa/CI a[3] 0.01364f
C376 bitslice\[17\].u_fa/a_952_112# bitslice\[19\].u_fa/CI 0.00107f
C377 bitslice\[9\].u_fa/a_1072_156# s[9] 0.0012f
C378 a[12] bitslice\[12\].u_fa/a_1072_156# 0.03894f
C379 bitslice\[6\].u_fa/a_124_46# bitslice\[6\].u_fa/CI 0.27486f
C380 bitslice\[11\].u_fa/a_1992_156# bitslice\[11\].u_fa/CI 0.69584f
C381 bitslice\[15\].u_fa/CI bitslice\[15\].u_fa/a_952_112# 2.44171f
C382 a[8] bitslice\[8\].u_fa/a_680_156# 0
C383 bitslice\[12\].u_fa/CI s[12] 0.00205f
C384 bitslice\[14\].u_fa/a_952_112# b[14] 0.78089f
C385 bitslice\[3\].u_fa/a_512_156# bitslice\[3\].u_fa/a_124_46# 0.00257f
C386 u_msb_x3/a_1336_472# b[21] 0
C387 bitslice\[16\].u_fa/a_124_46# bitslice\[15\].u_fa/a_124_46# 0.01624f
C388 s[18] bitslice\[18\].u_fa/a_124_46# 0.26234f
C389 VPWR bitslice\[17\].u_fa/a_3028_472# 0.00593f
C390 a[16] VPWR 0.67738f
C391 bitslice\[4\].u_fa/a_2012_472# bitslice\[4\].u_fa/a_952_112# 0.7796f
C392 bitslice\[2\].u_fa/a_952_112# bitslice\[3\].u_fa/CI 0.11504f
C393 a[6] bitslice\[7\].u_fa/a_952_112# 0
C394 bitslice\[14\].u_fa/a_124_46# b[15] 0
C395 a[0] bitslice\[0\].u_fa/a_1072_156# 0.03894f
C396 u_msb_x3/A3 u_msb_x3/a_728_93# 0.7716f
C397 VPWR bitslice\[11\].u_fa/a_680_156# 0
C398 bitslice\[9\].u_fa/CO bitslice\[10\].u_fa/a_2012_472# 0.00394f
C399 bitslice\[16\].u_fa/a_1072_496# bitslice\[16\].u_fa/a_952_112# 0.64312f
C400 bitslice\[9\].u_fa/CI bitslice\[9\].u_fa/a_1072_496# 0.00529f
C401 bitslice\[12\].u_fa/a_512_496# bitslice\[12\].u_fa/a_124_46# 0.00639f
C402 bitslice\[0\].u_fa/a_952_112# VPWR 0.59519f
C403 bitslice\[6\].u_fa/CI bitslice\[5\].u_fa/a_952_112# 0.1229f
C404 bitslice\[11\].u_fa/a_952_112# b[12] 0.00242f
C405 bitslice\[12\].u_fa/CI bitslice\[11\].u_fa/a_3028_472# 0
C406 u_msb_x3/a_244_524# u_msb_x3/A3 0
C407 s[6] a[7] 0.20011f
C408 bitslice\[3\].u_fa/CI b[3] 0.41328f
C409 bitslice\[20\].u_fa/a_952_112# bitslice\[20\].u_fa/a_3048_156# 0.00316f
C410 bitslice\[19\].u_fa/a_2012_472# bitslice\[19\].u_fa/a_3028_472# 0
C411 s[7] b[7] 0.00487f
C412 bitslice\[20\].u_fa/a_952_112# b[21] 0.00101f
C413 bitslice\[1\].u_fa/a_124_46# bitslice\[1\].u_fa/a_1072_156# 0.0288f
C414 bitslice\[9\].u_fa/a_2012_472# bitslice\[9\].u_fa/a_952_112# 0.7796f
C415 bitslice\[15\].u_fa/CI bitslice\[14\].u_fa/a_3028_472# 0.00124f
C416 VPWR s[3] 0.29039f
C417 bitslice\[9\].u_fa/CI b[8] 0.16737f
C418 a[1] bitslice\[2\].u_fa/a_124_46# 0
C419 bitslice\[9\].u_fa/CO bitslice\[10\].u_fa/a_3048_156# 0.00123f
C420 bitslice\[20\].u_fa/a_124_46# bitslice\[20\].u_fa/a_512_156# 0.00257f
C421 bitslice\[14\].u_fa/a_1072_496# b[14] 0.02505f
C422 s[21] u_msb_x3/a_1936_472# 0.33845f
C423 s[18] bitslice\[18\].u_fa/a_512_496# 0.00137f
C424 bitslice\[5\].u_fa/a_3028_472# bitslice\[4\].u_fa/CI 0
C425 bitslice\[11\].u_fa/a_2012_472# bitslice\[11\].u_fa/a_952_112# 0.7796f
C426 bitslice\[11\].u_fa/a_1072_496# bitslice\[11\].u_fa/a_512_496# 0
C427 bitslice\[0\].u_fa/a_952_112# bitslice\[1\].u_fa/CI 0.11627f
C428 bitslice\[4\].u_fa/a_512_496# bitslice\[4\].u_fa/a_124_46# 0.00639f
C429 a[21] u_msb_x3/a_1336_472# 0.02319f
C430 VPWR bitslice\[13\].u_fa/a_680_496# 0.00283f
C431 VPWR bitslice\[7\].u_fa/a_1072_156# 0.01572f
C432 VPWR a[4] 0.67821f
C433 bitslice\[20\].u_fa/a_1072_156# VPWR 0.01572f
C434 a[2] bitslice\[2\].u_fa/a_512_156# 0
C435 VPWR bitslice\[19\].u_fa/a_680_156# 0
C436 a[15] bitslice\[15\].u_fa/a_1992_156# 0.03757f
C437 bitslice\[11\].u_fa/a_952_112# a[11] 0.17786f
C438 s[4] bitslice\[4\].u_fa/a_1072_496# 0.00165f
C439 a[16] bitslice\[16\].u_fa/a_1072_496# 0.01952f
C440 b[10] bitslice\[10\].u_fa/a_124_46# 0.05484f
C441 bitslice\[11\].u_fa/a_3048_156# bitslice\[11\].u_fa/CI 0
C442 bitslice\[6\].u_fa/a_124_46# a[6] 0.60698f
C443 bitslice\[8\].u_fa/a_3028_472# bitslice\[9\].u_fa/CI 0.00242f
C444 s[21] s[20] 0
C445 a[8] bitslice\[9\].u_fa/CO 0.00117f
C446 bitslice\[20\].u_fa/a_952_112# a[21] 0.01016f
C447 bitslice\[15\].u_fa/CI bitslice\[14\].u_fa/CI 0.05228f
C448 bitslice\[2\].u_fa/CI bitslice\[2\].u_fa/a_2012_472# 0.00394f
C449 bitslice\[14\].u_fa/CI b[13] 0.08512f
C450 a[16] s[15] 0.19959f
C451 s[16] a[15] 0
C452 VPWR bitslice\[12\].u_fa/a_952_112# 0.59588f
C453 s[21] VPWR 0.23299f
C454 b[16] bitslice\[17\].u_fa/a_952_112# 0.00248f
C455 bitslice\[20\].u_fa/a_952_112# u_msb_x3/a_56_524# 0
C456 bitslice\[12\].u_fa/CI bitslice\[12\].u_fa/a_124_46# 0.27486f
C457 b[4] b[3] 0.1159f
C458 s[3] bitslice\[3\].u_fa/a_124_46# 0.26222f
C459 a[21] bitslice\[20\].u_fa/a_512_496# 0
C460 bitslice\[18\].u_fa/a_2012_472# u_msb_x3/A3 0
C461 bitslice\[5\].u_fa/a_1072_496# a[5] 0.02208f
C462 u_msb_x3/a_1936_472# VPWR 0.62899f
C463 bitslice\[13\].u_fa/a_952_112# a[12] 0
C464 a[8] bitslice\[9\].u_fa/a_952_112# 0
C465 bitslice\[16\].u_fa/CI bitslice\[16\].u_fa/a_1072_156# 0.61603f
C466 a[15] s[14] 0.20011f
C467 bitslice\[11\].u_fa/a_124_46# s[11] 0.26222f
C468 a[18] bitslice\[18\].u_fa/a_1992_156# 0.03766f
C469 VPWR bitslice\[6\].u_fa/a_2012_472# 0.29058f
C470 VPWR bitslice\[20\].u_fa/a_2012_472# 0.29058f
C471 a[2] bitslice\[2\].u_fa/a_1072_156# 0.03894f
C472 b[5] bitslice\[4\].u_fa/CI 0.00269f
C473 bitslice\[15\].u_fa/CI bitslice\[15\].u_fa/a_1072_156# 0.61608f
C474 a[4] bitslice\[3\].u_fa/a_124_46# 0.00806f
C475 bitslice\[11\].u_fa/a_124_46# bitslice\[12\].u_fa/a_124_46# 0.01624f
C476 bitslice\[0\].u_fa/a_124_46# bitslice\[1\].u_fa/a_124_46# 0.02943f
C477 bitslice\[9\].u_fa/a_2012_472# bitslice\[9\].u_fa/CI 0.01791f
C478 bitslice\[2\].u_fa/a_3028_472# bitslice\[3\].u_fa/CI 0.00124f
C479 s[7] bitslice\[7\].u_fa/a_512_496# 0
C480 bitslice\[17\].u_fa/a_1072_496# bitslice\[17\].u_fa/a_124_46# 0.0139f
C481 bitslice\[10\].u_fa/a_952_112# bitslice\[8\].u_fa/CI 0
C482 bitslice\[19\].u_fa/a_1072_496# bitslice\[19\].u_fa/a_952_112# 0.64312f
C483 s[20] VPWR 0.34859f
C484 a[10] bitslice\[10\].u_fa/a_512_156# 0
C485 a[0] bitslice\[0\].u_fa/a_512_496# 0
C486 bitslice\[17\].u_fa/CI bitslice\[17\].u_fa/a_1992_156# 0.69584f
C487 bitslice\[5\].u_fa/a_1072_156# bitslice\[5\].u_fa/a_952_112# 0.00934f
C488 bitslice\[14\].u_fa/a_1992_156# bitslice\[14\].u_fa/CI 0.70116f
C489 b[7] a[7] 0.46296f
C490 bitslice\[12\].u_fa/CI bitslice\[11\].u_fa/CI 0.0903f
C491 bitslice\[15\].u_fa/CI b[16] 0
C492 s[21] FILLER_21_2/a_124_375# 0.01419f
C493 bitslice\[6\].u_fa/CI bitslice\[6\].u_fa/a_1072_156# 0.61603f
C494 a[14] b[15] 0
C495 a[2] s[2] 0.17692f
C496 s[16] a[17] 0.20011f
C497 bitslice\[3\].u_fa/CI b[2] 0.09026f
C498 bitslice\[20\].u_fa/a_952_112# bitslice\[19\].u_fa/CI 0
C499 bitslice\[13\].u_fa/a_2012_472# bitslice\[13\].u_fa/a_1072_496# 0.00406f
C500 VPWR bitslice\[15\].u_fa/a_512_156# 0
C501 VPWR bitslice\[1\].u_fa/a_1072_496# 0.28074f
C502 bitslice\[2\].u_fa/a_680_156# bitslice\[2\].u_fa/a_124_46# 0.00316f
C503 b[19] VPWR 1.90176f
C504 a[3] bitslice\[2\].u_fa/a_124_46# 0.00783f
C505 bitslice\[0\].u_fa/a_124_46# bitslice\[0\].u_fa/a_1072_156# 0.0288f
C506 s[17] bitslice\[17\].u_fa/a_512_156# 0.00108f
C507 VPWR bitslice\[10\].u_fa/a_512_496# 0.00292f
C508 bitslice\[7\].u_fa/CI b[7] 0.41328f
C509 bitslice\[9\].u_fa/CO a[10] 0.22372f
C510 bitslice\[10\].u_fa/a_3048_156# bitslice\[9\].u_fa/CI 0
C511 bitslice\[10\].u_fa/a_1072_496# bitslice\[10\].u_fa/a_124_46# 0.0139f
C512 bitslice\[8\].u_fa/a_2012_472# bitslice\[8\].u_fa/a_1072_496# 0.00406f
C513 bitslice\[14\].u_fa/CI bitslice\[13\].u_fa/a_3048_156# 0.00149f
C514 a[12] bitslice\[12\].u_fa/a_680_496# 0
C515 bitslice\[13\].u_fa/CI bitslice\[12\].u_fa/a_952_112# 0.11504f
C516 bitslice\[11\].u_fa/a_124_46# bitslice\[11\].u_fa/CI 0.27486f
C517 bitslice\[12\].u_fa/CI bitslice\[12\].u_fa/a_1072_156# 0.61603f
C518 bitslice\[4\].u_fa/a_3028_472# bitslice\[5\].u_fa/CI 0.00135f
C519 b[4] bitslice\[4\].u_fa/a_1992_156# 0.03179f
C520 b[1] bitslice\[2\].u_fa/CI 0.08552f
C521 bitslice\[20\].u_fa/a_124_46# a[19] 0
C522 bitslice\[18\].u_fa/a_512_156# bitslice\[18\].u_fa/a_124_46# 0.00257f
C523 u_msb_x3/a_2215_68# u_msb_x3/a_1336_472# 0
C524 bitslice\[1\].u_fa/CI VPWR 0.93267f
C525 bitslice\[14\].u_fa/a_1072_156# VPWR 0.01572f
C526 bitslice\[1\].u_fa/CI bitslice\[1\].u_fa/a_1072_496# 0.00463f
C527 bitslice\[17\].u_fa/a_1072_496# a[17] 0.02208f
C528 s[4] bitslice\[4\].u_fa/a_952_112# 0.00117f
C529 bitslice\[14\].u_fa/CI a[13] 0.01383f
C530 bitslice\[13\].u_fa/a_1072_156# bitslice\[13\].u_fa/a_952_112# 0.00934f
C531 b[11] bitslice\[11\].u_fa/a_3028_472# 0.00428f
C532 bitslice\[14\].u_fa/CI b[12] 0.00259f
C533 a[8] bitslice\[9\].u_fa/CI 0.01671f
C534 bitslice\[2\].u_fa/a_1072_496# VPWR 0.28074f
C535 bitslice\[17\].u_fa/a_124_46# bitslice\[17\].u_fa/a_680_496# 0.00655f
C536 b[14] b[15] 0.83145f
C537 bitslice\[9\].u_fa/a_1992_156# a[9] 0.03757f
C538 bitslice\[8\].u_fa/a_952_112# VPWR 0.59588f
C539 a[20] bitslice\[20\].u_fa/a_1072_156# 0.03894f
C540 s[8] bitslice\[8\].u_fa/CI 0.00205f
C541 bitslice\[3\].u_fa/CI bitslice\[3\].u_fa/a_3028_472# 0.00336f
C542 bitslice\[18\].u_fa/CI bitslice\[16\].u_fa/CI 0.00156f
C543 VPWR bitslice\[16\].u_fa/a_1072_496# 0.28074f
C544 VPWR FILLER_21_2/a_124_375# 0.35066f
C545 bitslice\[4\].u_fa/a_1072_496# bitslice\[5\].u_fa/CI 0
C546 bitslice\[17\].u_fa/a_1072_156# bitslice\[17\].u_fa/a_124_46# 0.0288f
C547 s[5] b[5] 0.00392f
C548 bitslice\[9\].u_fa/CO a[9] 0.01629f
C549 a[6] bitslice\[6\].u_fa/a_1072_156# 0.03894f
C550 bitslice\[17\].u_fa/a_2012_472# bitslice\[17\].u_fa/a_952_112# 0.7796f
C551 VPWR bitslice\[3\].u_fa/a_124_46# 0.46957f
C552 VPWR bitslice\[14\].u_fa/a_2012_472# 0.29058f
C553 bitslice\[20\].u_fa/CI bitslice\[18\].u_fa/CI 0.00137f
C554 bitslice\[3\].u_fa/a_952_112# bitslice\[3\].u_fa/a_3048_156# 0.00316f
C555 bitslice\[7\].u_fa/a_1072_496# bitslice\[7\].u_fa/a_952_112# 0.64312f
C556 b[20] u_msb_x3/a_718_524# 0.00337f
C557 bitslice\[9\].u_fa/a_124_46# bitslice\[9\].u_fa/a_680_156# 0.00316f
C558 bitslice\[15\].u_fa/a_1992_156# bitslice\[15\].u_fa/a_1072_156# 0.00753f
C559 VPWR s[15] 0.29039f
C560 a[15] bitslice\[15\].u_fa/a_2012_472# 0.01751f
C561 s[15] bitslice\[15\].u_fa/a_512_156# 0.00108f
C562 a[19] bitslice\[19\].u_fa/a_1992_156# 0.03757f
C563 bitslice\[19\].u_fa/CI bitslice\[19\].u_fa/a_3028_472# 0.00336f
C564 a[21] bitslice\[20\].u_fa/a_680_496# 0
C565 s[1] bitslice\[1\].u_fa/a_124_46# 0.26222f
C566 b[1] bitslice\[1\].u_fa/a_952_112# 0.77779f
C567 VPWR bitslice\[13\].u_fa/CI 0.93267f
C568 s[12] s[13] 0.00769f
C569 a[20] s[21] 0
C570 bitslice\[2\].u_fa/a_3048_156# bitslice\[3\].u_fa/CI 0
C571 bitslice\[6\].u_fa/a_124_46# bitslice\[6\].u_fa/a_1072_156# 0.0288f
C572 bitslice\[7\].u_fa/a_512_496# a[7] 0.002f
C573 b[14] bitslice\[13\].u_fa/a_952_112# 0.0033f
C574 bitslice\[14\].u_fa/CI s[14] 0.00205f
C575 s[17] bitslice\[17\].u_fa/a_512_496# 0
C576 a[9] bitslice\[9\].u_fa/a_952_112# 0.17786f
C577 VPWR bitslice\[8\].u_fa/a_680_496# 0.00283f
C578 bitslice\[13\].u_fa/a_1072_496# bitslice\[13\].u_fa/a_952_112# 0.64312f
C579 bitslice\[14\].u_fa/a_124_46# a[15] 0.00783f
C580 VPWR s[18] 0.34826f
C581 a[17] bitslice\[17\].u_fa/a_680_496# 0.00136f
C582 b[11] s[11] 0.00392f
C583 bitslice\[16\].u_fa/a_124_46# bitslice\[16\].u_fa/a_1072_156# 0.0288f
C584 bitslice\[11\].u_fa/CI b[9] 0.00218f
C585 a[20] bitslice\[20\].u_fa/a_2012_472# 0.01748f
C586 bitslice\[1\].u_fa/CI bitslice\[1\].u_fa/a_3048_156# 0
C587 bitslice\[16\].u_fa/a_512_156# bitslice\[16\].u_fa/a_124_46# 0.00257f
C588 bitslice\[14\].u_fa/CI bitslice\[14\].u_fa/a_3048_156# 0.00102f
C589 bitslice\[12\].u_fa/a_1072_496# bitslice\[12\].u_fa/a_952_112# 0.64312f
C590 bitslice\[17\].u_fa/a_1072_156# a[17] 0.03679f
C591 u_msb_x3/a_728_93# FILLER_21_2/a_484_472# 0.00287f
C592 bitslice\[20\].u_fa/CI bitslice\[20\].u_fa/a_1072_496# 0.00434f
C593 bitslice\[8\].u_fa/CI bitslice\[7\].u_fa/a_3048_156# 0.00141f
C594 bitslice\[12\].u_fa/CI bitslice\[13\].u_fa/a_952_112# 0.00139f
C595 b[15] bitslice\[15\].u_fa/a_124_46# 0.05484f
C596 bitslice\[3\].u_fa/CI bitslice\[4\].u_fa/CI 0.0903f
C597 s[11] s[10] 0.00769f
C598 VPWR bitslice\[9\].u_fa/a_1072_496# 0.28074f
C599 b[10] bitslice\[8\].u_fa/CI 0
C600 b[12] bitslice\[12\].u_fa/a_1992_156# 0.03179f
C601 bitslice\[15\].u_fa/a_2012_472# bitslice\[15\].u_fa/a_952_112# 0.7796f
C602 a[1] s[2] 0
C603 bitslice\[10\].u_fa/a_952_112# b[9] 0.0025f
C604 bitslice\[20\].u_fa/a_124_46# FILLER_21_2/a_572_375# 0
C605 bitslice\[18\].u_fa/a_1992_156# bitslice\[18\].u_fa/a_1072_156# 0.00753f
C606 a[18] bitslice\[18\].u_fa/a_680_496# 0
C607 bitslice\[16\].u_fa/CI bitslice\[16\].u_fa/a_124_46# 0.27486f
C608 a[20] s[20] 0.17692f
C609 bitslice\[0\].u_fa/a_680_496# bitslice\[0\].u_fa/a_1072_496# 0
C610 s[16] b[16] 0.00338f
C611 a[2] bitslice\[2\].u_fa/CI 0.22372f
C612 bitslice\[0\].u_fa/a_512_496# bitslice\[0\].u_fa/a_124_46# 0.00639f
C613 a[10] bitslice\[9\].u_fa/CI 0.0019f
C614 bitslice\[17\].u_fa/a_952_112# bitslice\[16\].u_fa/a_952_112# 0.02943f
C615 bitslice\[11\].u_fa/a_2012_472# bitslice\[11\].u_fa/a_1072_496# 0.00406f
C616 bitslice\[20\].u_fa/CI u_msb_x3/a_728_93# 0
C617 bitslice\[13\].u_fa/a_512_156# VPWR 0
C618 bitslice\[0\].u_fa/a_952_112# s[0] 0.00117f
C619 bitslice\[4\].u_fa/a_680_496# bitslice\[4\].u_fa/a_1072_496# 0
C620 VPWR b[8] 1.89383f
C621 bitslice\[7\].u_fa/a_1072_156# bitslice\[7\].u_fa/a_124_46# 0.0288f
C622 bitslice\[4\].u_fa/CI bitslice\[4\].u_fa/a_124_46# 0.27486f
C623 b[2] bitslice\[2\].u_fa/a_1992_156# 0.03179f
C624 a[11] bitslice\[9\].u_fa/CO 0.00113f
C625 b[17] bitslice\[17\].u_fa/a_952_112# 0.77779f
C626 a[20] VPWR 0.68641f
C627 bitslice\[20\].u_fa/CI u_msb_x3/a_244_524# 0
C628 bitslice\[16\].u_fa/CI bitslice\[15\].u_fa/a_3048_156# 0.00141f
C629 b[18] u_msb_x3/A3 0
C630 bitslice\[11\].u_fa/a_1072_496# a[11] 0.02208f
C631 bitslice\[17\].u_fa/CI bitslice\[16\].u_fa/a_2012_472# 0
C632 b[5] bitslice\[5\].u_fa/a_124_46# 0.05484f
C633 bitslice\[5\].u_fa/a_1072_496# bitslice\[5\].u_fa/a_952_112# 0.64312f
C634 bitslice\[12\].u_fa/CI b[10] 0.00259f
C635 b[11] bitslice\[11\].u_fa/CI 0.41328f
C636 cin bitslice\[2\].u_fa/CI 0
C637 b[20] FILLER_21_2/a_572_375# 0.05689f
C638 a[0] b[0] 0.46601f
C639 bitslice\[3\].u_fa/a_952_112# bitslice\[2\].u_fa/CI 0.00139f
C640 bitslice\[9\].u_fa/CO bitslice\[9\].u_fa/a_3048_156# 0.00141f
C641 bitslice\[4\].u_fa/CI a[5] 0.00113f
C642 bitslice\[20\].u_fa/a_124_46# bitslice\[19\].u_fa/a_124_46# 0.01624f
C643 bitslice\[8\].u_fa/a_3028_472# VPWR 0.00593f
C644 VPWR bitslice\[12\].u_fa/a_1072_496# 0.28074f
C645 bitslice\[18\].u_fa/CI bitslice\[18\].u_fa/a_952_112# 2.42681f
C646 a[16] bitslice\[17\].u_fa/a_952_112# 0
C647 bitslice\[17\].u_fa/a_952_112# bitslice\[17\].u_fa/a_3028_472# 0.00197f
C648 bitslice\[11\].u_fa/a_124_46# b[10] 0
C649 b[11] bitslice\[10\].u_fa/a_952_112# 0.00226f
C650 bitslice\[12\].u_fa/a_3048_156# bitslice\[12\].u_fa/a_952_112# 0.00316f
C651 bitslice\[0\].u_fa/a_952_112# b[1] 0.00226f
C652 bitslice\[3\].u_fa/a_952_112# bitslice\[5\].u_fa/CI 0
C653 bitslice\[15\].u_fa/CI bitslice\[16\].u_fa/a_952_112# 0
C654 b[20] b[21] 0.10231f
C655 bitslice\[9\].u_fa/CI a[9] 0.21934f
C656 bitslice\[13\].u_fa/a_680_496# bitslice\[13\].u_fa/a_124_46# 0.00655f
C657 a[0] bitslice\[0\].u_fa/a_2012_472# 0.01748f
C658 bitslice\[4\].u_fa/a_952_112# bitslice\[5\].u_fa/CI 0.11743f
C659 bitslice\[8\].u_fa/a_952_112# b[8] 0.77863f
C660 bitslice\[20\].u_fa/a_124_46# a[21] 0.01419f
C661 bitslice\[1\].u_fa/a_1992_156# bitslice\[1\].u_fa/a_1072_156# 0.00753f
C662 bitslice\[14\].u_fa/a_680_496# VPWR 0.00283f
C663 bitslice\[4\].u_fa/CI b[4] 0.34555f
C664 bitslice\[11\].u_fa/a_680_496# s[11] 0
C665 bitslice\[9\].u_fa/a_3048_156# bitslice\[9\].u_fa/a_952_112# 0.00316f
C666 a[20] FILLER_21_2/a_124_375# 0.00179f
C667 bitslice\[0\].u_fa/a_3028_472# b[0] 0.00428f
C668 bitslice\[10\].u_fa/a_952_112# s[10] 0.00117f
C669 bitslice\[11\].u_fa/a_3048_156# bitslice\[11\].u_fa/a_952_112# 0.00316f
C670 b[7] bitslice\[7\].u_fa/a_3028_472# 0.00428f
C671 cin bitslice\[1\].u_fa/a_952_112# 0
C672 bitslice\[9\].u_fa/a_124_46# bitslice\[9\].u_fa/a_512_156# 0.00257f
C673 a[19] u_msb_x3/A3 0.00478f
C674 bitslice\[8\].u_fa/a_3028_472# bitslice\[8\].u_fa/a_952_112# 0.00197f
C675 VPWR bitslice\[2\].u_fa/a_2012_472# 0.29058f
C676 bitslice\[12\].u_fa/a_952_112# bitslice\[12\].u_fa/a_3028_472# 0.00197f
C677 bitslice\[11\].u_fa/a_512_156# s[11] 0.00108f
C678 VPWR bitslice\[9\].u_fa/a_2012_472# 0.29058f
C679 u_msb_x3/A3 u_msb_x3/a_718_524# 0.00666f
C680 b[20] a[21] 0.02169f
C681 bitslice\[0\].u_fa/a_2012_472# bitslice\[0\].u_fa/a_3028_472# 0
C682 bitslice\[11\].u_fa/CI bitslice\[10\].u_fa/a_3028_472# 0.00124f
C683 a[10] bitslice\[10\].u_fa/a_1992_156# 0.03766f
C684 bitslice\[20\].u_fa/a_1992_156# b[20] 0.03179f
C685 bitslice\[2\].u_fa/a_512_496# VPWR 0.00292f
C686 bitslice\[15\].u_fa/CI a[16] 0.00171f
C687 a[4] bitslice\[4\].u_fa/a_1072_496# 0.01952f
C688 bitslice\[14\].u_fa/a_124_46# bitslice\[14\].u_fa/CI 0.27486f
C689 a[14] a[15] 0.04751f
C690 bitslice\[9\].u_fa/CI a[7] 0.00267f
C691 VPWR bitslice\[7\].u_fa/a_124_46# 0.46957f
C692 a[21] bitslice\[19\].u_fa/a_1992_156# 0
C693 bitslice\[2\].u_fa/a_952_112# b[3] 0.00226f
C694 u_msb_x3/a_56_524# b[20] 0.00644f
C695 a[3] s[2] 0.20011f
C696 bitslice\[5\].u_fa/a_512_496# VPWR 0.00292f
C697 VPWR bitslice\[10\].u_fa/a_2012_472# 0.29058f
C698 bitslice\[2\].u_fa/a_680_156# s[2] 0
C699 bitslice\[18\].u_fa/CI bitslice\[18\].u_fa/a_3048_156# 0.00108f
C700 bitslice\[10\].u_fa/a_512_156# bitslice\[10\].u_fa/a_124_46# 0.00257f
C701 bitslice\[10\].u_fa/a_3028_472# bitslice\[10\].u_fa/a_952_112# 0.00197f
C702 bitslice\[10\].u_fa/a_1072_496# bitslice\[10\].u_fa/a_680_496# 0
C703 bitslice\[6\].u_fa/a_952_112# s[6] 0.00117f
C704 s[4] a[3] 0
C705 bitslice\[7\].u_fa/CI bitslice\[9\].u_fa/CI 0.00536f
C706 bitslice\[19\].u_fa/a_2012_472# u_msb_x3/A3 0.00182f
C707 bitslice\[17\].u_fa/a_1992_156# a[17] 0.03757f
C708 s[5] a[5] 0.1788f
C709 bitslice\[19\].u_fa/a_3048_156# bitslice\[19\].u_fa/CI 0
C710 bitslice\[2\].u_fa/a_1072_496# bitslice\[2\].u_fa/a_2012_472# 0.00406f
C711 a[1] bitslice\[2\].u_fa/CI 0.01364f
C712 VPWR bitslice\[15\].u_fa/a_512_496# 0.00292f
C713 VPWR bitslice\[18\].u_fa/a_512_156# 0
C714 b[10] b[9] 0.1159f
C715 VPWR s[0] 0.34826f
C716 VPWR bitslice\[11\].u_fa/a_512_496# 0.00292f
C717 s[9] bitslice\[9\].u_fa/a_680_496# 0
C718 bitslice\[9\].u_fa/CO bitslice\[10\].u_fa/a_124_46# 0.27486f
C719 bitslice\[2\].u_fa/a_512_496# bitslice\[2\].u_fa/a_1072_496# 0
C720 bitslice\[12\].u_fa/CI bitslice\[11\].u_fa/a_952_112# 0.1229f
C721 a[14] bitslice\[15\].u_fa/a_952_112# 0
C722 bitslice\[5\].u_fa/a_3048_156# bitslice\[5\].u_fa/CI 0
C723 s[7] bitslice\[7\].u_fa/a_1072_156# 0.0012f
C724 bitslice\[9\].u_fa/CI bitslice\[9\].u_fa/a_3048_156# 0
C725 VPWR bitslice\[12\].u_fa/a_3028_472# 0.00593f
C726 bitslice\[17\].u_fa/a_2012_472# bitslice\[17\].u_fa/a_1072_496# 0.00406f
C727 VPWR bitslice\[13\].u_fa/a_124_46# 0.46957f
C728 b[7] bitslice\[7\].u_fa/a_1992_156# 0.03179f
C729 b[14] a[15] 0
C730 bitslice\[18\].u_fa/CI bitslice\[18\].u_fa/a_2012_472# 0.00394f
C731 VPWR bitslice\[4\].u_fa/a_3028_472# 0.00593f
C732 bitslice\[20\].u_fa/a_952_112# bitslice\[20\].u_fa/a_3028_472# 0.00197f
C733 VPWR bitslice\[8\].u_fa/a_124_46# 0.46952f
C734 bitslice\[18\].u_fa/a_3048_156# bitslice\[18\].u_fa/a_952_112# 0.00316f
C735 bitslice\[3\].u_fa/a_1072_496# s[3] 0
C736 a[8] VPWR 0.67821f
C737 s[8] s[9] 0.00791f
C738 s[6] b[6] 0.00338f
C739 bitslice\[11\].u_fa/a_952_112# bitslice\[11\].u_fa/a_124_46# 0.01486f
C740 a[2] s[3] 0
C741 b[20] bitslice\[19\].u_fa/CI 0
C742 bitslice\[0\].u_fa/a_124_46# b[0] 0.05484f
C743 VPWR bitslice\[15\].u_fa/a_680_496# 0.00283f
C744 bitslice\[12\].u_fa/a_952_112# b[13] 0.00226f
C745 bitslice\[8\].u_fa/a_3028_472# b[8] 0.00428f
C746 VPWR bitslice\[7\].u_fa/a_680_156# 0
C747 VPWR bitslice\[19\].u_fa/a_952_112# 0.59588f
C748 bitslice\[5\].u_fa/a_680_156# VPWR 0
C749 VPWR b[1] 1.90176f
C750 bitslice\[16\].u_fa/a_1992_156# bitslice\[16\].u_fa/a_1072_156# 0.00753f
C751 bitslice\[16\].u_fa/CI bitslice\[15\].u_fa/a_3028_472# 0
C752 VPWR bitslice\[11\].u_fa/a_1072_156# 0.01572f
C753 FILLER_21_2/a_572_375# u_msb_x3/A3 0.0023f
C754 bitslice\[18\].u_fa/a_3028_472# u_msb_x3/A3 0
C755 a[1] bitslice\[1\].u_fa/a_952_112# 0.17786f
C756 s[1] bitslice\[1\].u_fa/a_680_496# 0
C757 b[1] bitslice\[1\].u_fa/a_1072_496# 0.02505f
C758 bitslice\[9\].u_fa/a_124_46# bitslice\[9\].u_fa/a_952_112# 0.01486f
C759 b[19] bitslice\[19\].u_fa/a_952_112# 0.77779f
C760 bitslice\[19\].u_fa/CI bitslice\[19\].u_fa/a_1992_156# 0.69584f
C761 cin bitslice\[0\].u_fa/a_952_112# 2.36749f
C762 VPWR bitslice\[17\].u_fa/a_952_112# 0.59588f
C763 s[16] bitslice\[16\].u_fa/a_952_112# 0.00117f
C764 bitslice\[14\].u_fa/a_512_496# s[14] 0.00137f
C765 bitslice\[13\].u_fa/a_3028_472# bitslice\[13\].u_fa/a_2012_472# 0
C766 bitslice\[7\].u_fa/a_2012_472# a[7] 0.01751f
C767 b[11] b[10] 0.83145f
C768 bitslice\[13\].u_fa/CI bitslice\[12\].u_fa/a_3048_156# 0
C769 a[0] bitslice\[0\].u_fa/a_1072_496# 0.01952f
C770 VPWR bitslice\[4\].u_fa/a_1072_496# 0.28074f
C771 bitslice\[5\].u_fa/a_124_46# bitslice\[4\].u_fa/a_124_46# 0.02943f
C772 bitslice\[18\].u_fa/a_2012_472# bitslice\[18\].u_fa/a_952_112# 0.7796f
C773 bitslice\[20\].u_fa/a_680_156# s[20] 0
C774 b[14] bitslice\[15\].u_fa/a_952_112# 0.00248f
C775 bitslice\[3\].u_fa/a_952_112# s[3] 0.00139f
C776 bitslice\[20\].u_fa/a_3048_156# u_msb_x3/A3 0
C777 bitslice\[8\].u_fa/a_952_112# bitslice\[8\].u_fa/a_124_46# 0.01486f
C778 b[21] u_msb_x3/A3 0.05787f
C779 bitslice\[4\].u_fa/a_3048_156# bitslice\[4\].u_fa/a_952_112# 0.00316f
C780 s[15] bitslice\[15\].u_fa/a_512_496# 0
C781 bitslice\[2\].u_fa/a_3028_472# bitslice\[2\].u_fa/a_952_112# 0.00197f
C782 s[19] bitslice\[19\].u_fa/a_512_496# 0
C783 bitslice\[7\].u_fa/CI bitslice\[7\].u_fa/a_2012_472# 0.00772f
C784 bitslice\[16\].u_fa/a_1992_156# bitslice\[16\].u_fa/CI 0.70111f
C785 bitslice\[1\].u_fa/CI b[1] 0.41328f
C786 b[10] s[10] 0.00338f
C787 bitslice\[16\].u_fa/a_3028_472# bitslice\[16\].u_fa/a_2012_472# 0
C788 bitslice\[9\].u_fa/a_2012_472# bitslice\[9\].u_fa/a_1072_496# 0.00406f
C789 a[8] bitslice\[8\].u_fa/a_952_112# 0.17729f
C790 bitslice\[17\].u_fa/a_124_46# bitslice\[17\].u_fa/a_512_156# 0.00257f
C791 bitslice\[20\].u_fa/a_680_156# VPWR 0
C792 bitslice\[13\].u_fa/a_952_112# s[13] 0.00139f
C793 bitslice\[5\].u_fa/a_124_46# a[5] 0.60604f
C794 bitslice\[8\].u_fa/CI b[7] 0.08552f
C795 bitslice\[1\].u_fa/a_3028_472# bitslice\[1\].u_fa/a_2012_472# 0
C796 u_msb_x3/a_1524_472# a[21] 0
C797 bitslice\[18\].u_fa/a_1072_496# bitslice\[18\].u_fa/a_680_496# 0
C798 a[4] bitslice\[4\].u_fa/a_952_112# 0.17729f
C799 a[15] bitslice\[15\].u_fa/a_124_46# 0.60604f
C800 a[14] bitslice\[14\].u_fa/CI 0.22225f
C801 bitslice\[2\].u_fa/a_952_112# b[2] 0.77989f
C802 bitslice\[6\].u_fa/a_952_112# b[7] 0.00226f
C803 bitslice\[13\].u_fa/CI bitslice\[13\].u_fa/a_124_46# 0.27486f
C804 s[18] bitslice\[18\].u_fa/a_512_156# 0
C805 bitslice\[13\].u_fa/CI bitslice\[12\].u_fa/a_3028_472# 0.00124f
C806 a[12] bitslice\[12\].u_fa/a_1992_156# 0.03766f
C807 a[16] s[16] 0.17692f
C808 bitslice\[4\].u_fa/CI bitslice\[5\].u_fa/a_952_112# 0.00139f
C809 bitslice\[15\].u_fa/CI VPWR 0.93267f
C810 bitslice\[14\].u_fa/a_3028_472# b[14] 0.00428f
C811 b[17] bitslice\[17\].u_fa/a_1072_496# 0.02505f
C812 VPWR b[13] 1.90176f
C813 VPWR bitslice\[0\].u_fa/a_680_156# 0
C814 b[2] b[3] 0.83145f
C815 bitslice\[19\].u_fa/a_1072_156# s[19] 0
C816 s[15] bitslice\[15\].u_fa/a_680_496# 0
C817 bitslice\[13\].u_fa/a_680_496# a[13] 0.00136f
C818 bitslice\[7\].u_fa/a_3048_156# bitslice\[7\].u_fa/a_952_112# 0.00316f
C819 bitslice\[2\].u_fa/CI a[3] 0.00113f
C820 s[6] a[5] 0
C821 bitslice\[5\].u_fa/a_124_46# b[4] 0
C822 bitslice\[20\].u_fa/a_952_112# bitslice\[20\].u_fa/a_1072_156# 0.00934f
C823 VPWR s[7] 0.29812f
C824 bitslice\[20\].u_fa/a_1992_156# u_msb_x3/A3 0.00699f
C825 a[21] u_msb_x3/A3 0.23823f
C826 bitslice\[16\].u_fa/CI b[15] 0.08552f
C827 a[18] u_msb_x3/A3 0
C828 VPWR a[10] 0.67821f
C829 bitslice\[8\].u_fa/a_124_46# bitslice\[8\].u_fa/a_680_496# 0.00655f
C830 s[21] u_msb_x3/a_1336_472# 0.0257f
C831 a[10] bitslice\[10\].u_fa/a_512_496# 0
C832 b[10] bitslice\[10\].u_fa/a_3028_472# 0.00428f
C833 bitslice\[7\].u_fa/a_1072_156# a[7] 0.03679f
C834 a[8] bitslice\[8\].u_fa/a_680_496# 0
C835 u_msb_x3/a_56_524# u_msb_x3/A3 0.00551f
C836 u_msb_x3/a_1936_472# u_msb_x3/a_1336_472# 0.00462f
C837 bitslice\[15\].u_fa/a_952_112# bitslice\[15\].u_fa/a_124_46# 0.01486f
C838 s[12] s[11] 0.00743f
C839 bitslice\[9\].u_fa/a_124_46# bitslice\[9\].u_fa/CI 0.27486f
C840 b[6] b[7] 0.83145f
C841 bitslice\[17\].u_fa/CI bitslice\[16\].u_fa/CI 0.06088f
C842 bitslice\[3\].u_fa/a_1072_496# VPWR 0.28074f
C843 bitslice\[7\].u_fa/CI bitslice\[7\].u_fa/a_1072_156# 0.61608f
C844 bitslice\[1\].u_fa/a_680_496# bitslice\[1\].u_fa/a_124_46# 0.00655f
C845 bitslice\[12\].u_fa/a_952_112# a[13] 0
C846 b[14] bitslice\[14\].u_fa/CI 0.32458f
C847 s[5] a[6] 0.19959f
C848 bitslice\[17\].u_fa/a_952_112# bitslice\[17\].u_fa/a_3048_156# 0.00316f
C849 s[12] bitslice\[12\].u_fa/a_124_46# 0.26234f
C850 b[12] bitslice\[12\].u_fa/a_952_112# 0.77989f
C851 s[6] bitslice\[6\].u_fa/a_1072_496# 0.00165f
C852 a[2] VPWR 0.67821f
C853 bitslice\[13\].u_fa/a_512_156# bitslice\[13\].u_fa/a_124_46# 0.00257f
C854 bitslice\[13\].u_fa/a_3028_472# bitslice\[13\].u_fa/a_952_112# 0.00197f
C855 bitslice\[0\].u_fa/a_952_112# a[1] 0
C856 bitslice\[20\].u_fa/CI b[18] 0.00259f
C857 VPWR bitslice\[6\].u_fa/a_680_496# 0.00283f
C858 bitslice\[8\].u_fa/a_124_46# b[8] 0.05484f
C859 b[4] bitslice\[4\].u_fa/a_2012_472# 0.02435f
C860 bitslice\[15\].u_fa/CI bitslice\[14\].u_fa/a_2012_472# 0
C861 a[4] bitslice\[4\].u_fa/a_1072_156# 0.03894f
C862 bitslice\[14\].u_fa/a_1072_496# bitslice\[14\].u_fa/a_952_112# 0.64312f
C863 bitslice\[18\].u_fa/a_680_496# bitslice\[18\].u_fa/a_124_46# 0.00655f
C864 bitslice\[20\].u_fa/a_952_112# bitslice\[20\].u_fa/a_2012_472# 0.7796f
C865 a[8] b[8] 0.46601f
C866 VPWR bitslice\[6\].u_fa/a_680_156# 0
C867 bitslice\[17\].u_fa/a_124_46# bitslice\[17\].u_fa/a_512_496# 0.00639f
C868 VPWR a[9] 0.76087f
C869 VPWR bitslice\[3\].u_fa/a_2012_472# 0.29058f
C870 bitslice\[3\].u_fa/a_3028_472# b[3] 0.00428f
C871 bitslice\[10\].u_fa/a_1072_496# s[10] 0.00165f
C872 bitslice\[15\].u_fa/CI s[15] 0.00239f
C873 b[11] bitslice\[11\].u_fa/a_952_112# 0.77779f
C874 bitslice\[1\].u_fa/CI a[2] 0.00171f
C875 bitslice\[5\].u_fa/a_3028_472# bitslice\[5\].u_fa/CI 0.00336f
C876 b[17] bitslice\[17\].u_fa/a_1072_156# 0.0302f
C877 bitslice\[2\].u_fa/a_3048_156# bitslice\[2\].u_fa/a_952_112# 0.00316f
C878 cin VPWR 0.47383f
C879 u_msb_x3/a_1336_472# VPWR 0.17918f
C880 bitslice\[13\].u_fa/CI b[13] 0.41328f
C881 bitslice\[3\].u_fa/a_952_112# VPWR 0.59588f
C882 VPWR bitslice\[4\].u_fa/a_952_112# 0.59588f
C883 bitslice\[20\].u_fa/a_952_112# s[20] 0.00117f
C884 bitslice\[9\].u_fa/CI bitslice\[7\].u_fa/a_3028_472# 0
C885 bitslice\[19\].u_fa/CI u_msb_x3/A3 0.00658f
C886 bitslice\[14\].u_fa/a_1072_156# bitslice\[14\].u_fa/a_1992_156# 0.00753f
C887 s[5] bitslice\[5\].u_fa/a_1072_156# 0
C888 s[5] bitslice\[5\].u_fa/a_952_112# 0.00139f
C889 b[5] bitslice\[5\].u_fa/a_1992_156# 0.03179f
C890 bitslice\[8\].u_fa/a_512_496# bitslice\[8\].u_fa/a_1072_496# 0
C891 a[2] bitslice\[2\].u_fa/a_1072_496# 0.01952f
C892 bitslice\[5\].u_fa/a_680_496# a[5] 0.00136f
C893 bitslice\[14\].u_fa/a_512_496# bitslice\[14\].u_fa/a_124_46# 0.00639f
C894 a[6] bitslice\[6\].u_fa/a_512_156# 0
C895 bitslice\[7\].u_fa/CI bitslice\[6\].u_fa/a_2012_472# 0
C896 bitslice\[6\].u_fa/CI s[6] 0.00205f
C897 s[8] bitslice\[8\].u_fa/a_512_156# 0
C898 bitslice\[0\].u_fa/a_124_46# bitslice\[0\].u_fa/a_1072_496# 0.0139f
C899 bitslice\[2\].u_fa/a_3028_472# b[2] 0.00428f
C900 bitslice\[3\].u_fa/a_1072_496# bitslice\[3\].u_fa/a_124_46# 0.0139f
C901 bitslice\[20\].u_fa/a_952_112# VPWR 0.61042f
C902 bitslice\[20\].u_fa/a_952_112# b[19] 0.0025f
C903 VPWR bitslice\[7\].u_fa/a_680_496# 0.00283f
C904 cin bitslice\[1\].u_fa/CI 0.00414f
C905 bitslice\[9\].u_fa/CO bitslice\[8\].u_fa/CI 0.02143f
C906 VPWR a[13] 0.76087f
C907 VPWR bitslice\[1\].u_fa/a_680_156# 0
C908 a[2] bitslice\[3\].u_fa/a_124_46# 0
C909 VPWR bitslice\[10\].u_fa/a_680_156# 0
C910 a[19] bitslice\[19\].u_fa/a_512_496# 0.002f
C911 bitslice\[8\].u_fa/a_952_112# a[9] 0
C912 bitslice\[14\].u_fa/a_512_156# VPWR 0
C913 VPWR b[12] 1.90361f
C914 FILLER_21_2/a_36_472# FILLER_21_2/a_484_472# 0.01328f
C915 s[20] bitslice\[20\].u_fa/a_512_496# 0.00137f
C916 bitslice\[18\].u_fa/CI bitslice\[17\].u_fa/CI 0.0487f
C917 bitslice\[18\].u_fa/CI b[18] 0.40928f
C918 bitslice\[10\].u_fa/a_1072_156# bitslice\[10\].u_fa/a_952_112# 0.00934f
C919 bitslice\[11\].u_fa/a_3028_472# bitslice\[11\].u_fa/CI 0.00336f
C920 a[12] bitslice\[12\].u_fa/a_512_156# 0
C921 bitslice\[6\].u_fa/a_124_46# bitslice\[6\].u_fa/a_512_156# 0.00257f
C922 bitslice\[17\].u_fa/a_512_496# a[17] 0.002f
C923 bitslice\[20\].u_fa/CI a[19] 0.01364f
C924 VPWR a[7] 0.75828f
C925 a[20] bitslice\[20\].u_fa/a_680_156# 0
C926 b[15] bitslice\[15\].u_fa/a_1072_496# 0.02505f
C927 bitslice\[16\].u_fa/a_124_46# bitslice\[16\].u_fa/a_680_156# 0.00316f
C928 bitslice\[20\].u_fa/CI u_msb_x3/a_718_524# 0.00119f
C929 s[5] bitslice\[5\].u_fa/a_512_156# 0.00108f
C930 VPWR bitslice\[20\].u_fa/a_512_496# 0.00292f
C931 s[16] VPWR 0.34826f
C932 bitslice\[4\].u_fa/CI b[3] 0.08552f
C933 bitslice\[1\].u_fa/a_124_46# b[0] 0
C934 VPWR bitslice\[7\].u_fa/CI 0.93267f
C935 VPWR bitslice\[11\].u_fa/a_2012_472# 0.29058f
C936 u_msb_x3/a_2215_68# u_msb_x3/A3 0
C937 bitslice\[5\].u_fa/a_124_46# a[6] 0.00806f
C938 bitslice\[16\].u_fa/a_680_496# bitslice\[16\].u_fa/a_124_46# 0.00655f
C939 bitslice\[8\].u_fa/CI bitslice\[9\].u_fa/a_952_112# 0.00465f
C940 bitslice\[9\].u_fa/a_680_156# s[9] 0
C941 bitslice\[3\].u_fa/a_952_112# bitslice\[3\].u_fa/a_124_46# 0.01486f
C942 a[19] bitslice\[19\].u_fa/a_1072_156# 0.03679f
C943 b[5] bitslice\[5\].u_fa/CI 0.40995f
C944 VPWR a[11] 0.76087f
C945 bitslice\[15\].u_fa/a_1072_156# bitslice\[15\].u_fa/a_124_46# 0.0288f
C946 s[8] bitslice\[8\].u_fa/a_1072_496# 0.00165f
C947 bitslice\[8\].u_fa/a_124_46# bitslice\[7\].u_fa/a_124_46# 0.01624f
C948 VPWR bitslice\[4\].u_fa/a_1072_156# 0.01572f
C949 VPWR s[14] 0.34826f
C950 b[18] bitslice\[18\].u_fa/a_952_112# 0.77697f
C951 bitslice\[12\].u_fa/CI bitslice\[12\].u_fa/a_1992_156# 0.70111f
C952 bitslice\[13\].u_fa/a_3048_156# bitslice\[13\].u_fa/CI 0
C953 bitslice\[17\].u_fa/CI bitslice\[18\].u_fa/a_952_112# 0.0048f
C954 bitslice\[9\].u_fa/CO bitslice\[9\].u_fa/a_3028_472# 0.001f
C955 bitslice\[6\].u_fa/a_124_46# bitslice\[5\].u_fa/a_124_46# 0.01624f
C956 a[8] bitslice\[7\].u_fa/a_124_46# 0.00806f
C957 a[6] s[6] 0.17692f
C958 bitslice\[17\].u_fa/a_680_156# s[17] 0
C959 bitslice\[11\].u_fa/a_1072_496# bitslice\[11\].u_fa/a_124_46# 0.0139f
C960 bitslice\[17\].u_fa/a_1072_496# VPWR 0.28074f
C961 bitslice\[3\].u_fa/a_512_496# s[3] 0
C962 bitslice\[7\].u_fa/a_3028_472# bitslice\[7\].u_fa/a_2012_472# 0
C963 bitslice\[7\].u_fa/a_680_156# bitslice\[7\].u_fa/a_124_46# 0.00316f
C964 b[0] bitslice\[0\].u_fa/a_1072_156# 0.0302f
C965 bitslice\[11\].u_fa/CI s[11] 0.00239f
C966 VPWR a[1] 0.76087f
C967 s[4] bitslice\[4\].u_fa/a_124_46# 0.26234f
C968 VPWR bitslice\[19\].u_fa/a_3028_472# 0.00593f
C969 a[19] bitslice\[18\].u_fa/CI 0.00242f
C970 a[3] s[3] 0.1788f
C971 b[19] bitslice\[19\].u_fa/a_3028_472# 0.00428f
C972 bitslice\[8\].u_fa/a_952_112# bitslice\[7\].u_fa/CI 0
C973 a[1] bitslice\[1\].u_fa/a_1072_496# 0.02208f
C974 bitslice\[5\].u_fa/a_3028_472# bitslice\[5\].u_fa/a_2012_472# 0
C975 bitslice\[5\].u_fa/a_1072_156# bitslice\[5\].u_fa/a_124_46# 0.0288f
C976 a[9] bitslice\[9\].u_fa/a_1072_496# 0.02208f
C977 bitslice\[13\].u_fa/CI a[13] 0.22669f
C978 bitslice\[14\].u_fa/CI bitslice\[13\].u_fa/a_1992_156# 0
C979 bitslice\[5\].u_fa/a_124_46# bitslice\[5\].u_fa/a_952_112# 0.01486f
C980 a[16] bitslice\[16\].u_fa/a_512_496# 0
C981 s[16] bitslice\[16\].u_fa/a_1072_496# 0.00165f
C982 b[16] bitslice\[16\].u_fa/a_2012_472# 0.02435f
C983 bitslice\[6\].u_fa/a_124_46# s[6] 0.26234f
C984 bitslice\[3\].u_fa/a_680_496# s[3] 0
C985 bitslice\[3\].u_fa/CI bitslice\[3\].u_fa/a_3048_156# 0
C986 bitslice\[13\].u_fa/CI b[12] 0.09026f
C987 bitslice\[9\].u_fa/a_3028_472# bitslice\[9\].u_fa/a_952_112# 0.00197f
C988 FILLER_21_2/a_572_375# FILLER_21_2/a_484_472# 0.30831f
C989 a[9] b[8] 0
C990 a[4] a[3] 0.86295f
C991 s[4] a[5] 0.20011f
C992 s[19] bitslice\[19\].u_fa/a_512_156# 0.00108f
C993 bitslice\[13\].u_fa/a_680_156# s[13] 0
C994 bitslice\[6\].u_fa/CI b[7] 0.00269f
C995 s[16] s[15] 0.00743f
C996 bitslice\[3\].u_fa/a_1072_156# s[3] 0
C997 bitslice\[4\].u_fa/CI bitslice\[4\].u_fa/a_1992_156# 0.70111f
C998 bitslice\[1\].u_fa/CI a[1] 0.22669f
C999 bitslice\[6\].u_fa/a_3028_472# bitslice\[9\].u_fa/CI 0
C1000 bitslice\[12\].u_fa/a_1072_156# bitslice\[12\].u_fa/a_124_46# 0.0288f
C1001 a[8] bitslice\[8\].u_fa/a_124_46# 0.60698f
C1002 b[20] bitslice\[20\].u_fa/a_3028_472# 0.00428f
C1003 bitslice\[14\].u_fa/a_952_112# b[15] 0.00226f
C1004 bitslice\[6\].u_fa/a_952_112# bitslice\[5\].u_fa/CI 0
C1005 b[17] bitslice\[17\].u_fa/a_1992_156# 0.03179f
C1006 bitslice\[5\].u_fa/a_124_46# bitslice\[5\].u_fa/a_512_156# 0.00257f
C1007 bitslice\[14\].u_fa/a_512_496# a[14] 0
C1008 bitslice\[8\].u_fa/a_1992_156# b[8] 0.03179f
C1009 s[15] s[14] 0.00769f
C1010 a[19] bitslice\[18\].u_fa/a_952_112# 0
C1011 s[4] b[4] 0.00338f
C1012 VPWR bitslice\[8\].u_fa/a_1072_156# 0.01572f
C1013 bitslice\[9\].u_fa/CI bitslice\[8\].u_fa/CI 0.04745f
C1014 bitslice\[16\].u_fa/CI bitslice\[16\].u_fa/a_3028_472# 0.00135f
C1015 a[18] bitslice\[18\].u_fa/a_680_156# 0
C1016 bitslice\[17\].u_fa/CI bitslice\[18\].u_fa/a_3048_156# 0
C1017 bitslice\[20\].u_fa/a_3048_156# bitslice\[20\].u_fa/CI 0.00123f
C1018 bitslice\[6\].u_fa/a_952_112# bitslice\[9\].u_fa/CI 0
C1019 bitslice\[20\].u_fa/CI b[21] 0.00663f
C1020 bitslice\[6\].u_fa/a_512_496# bitslice\[6\].u_fa/a_1072_496# 0
C1021 s[20] bitslice\[20\].u_fa/a_680_496# 0
C1022 VPWR bitslice\[17\].u_fa/a_680_496# 0.00283f
C1023 bitslice\[4\].u_fa/a_680_156# bitslice\[4\].u_fa/a_124_46# 0.00316f
C1024 VPWR bitslice\[9\].u_fa/a_512_496# 0.00292f
C1025 bitslice\[9\].u_fa/a_1992_156# b[9] 0.03179f
C1026 s[7] bitslice\[7\].u_fa/a_124_46# 0.27423f
C1027 b[7] bitslice\[7\].u_fa/a_952_112# 0.77779f
C1028 bitslice\[20\].u_fa/a_952_112# a[20] 0.17729f
C1029 bitslice\[17\].u_fa/a_1072_156# VPWR 0.01572f
C1030 b[2] bitslice\[4\].u_fa/CI 0.00259f
C1031 bitslice\[16\].u_fa/CI a[15] 0.01364f
C1032 bitslice\[19\].u_fa/a_512_496# bitslice\[19\].u_fa/a_124_46# 0.00639f
C1033 bitslice\[1\].u_fa/a_124_46# bitslice\[2\].u_fa/a_124_46# 0.01624f
C1034 bitslice\[9\].u_fa/CO b[9] 0.09033f
C1035 bitslice\[14\].u_fa/a_952_112# bitslice\[13\].u_fa/a_952_112# 0.03505f
C1036 s[5] bitslice\[5\].u_fa/a_1072_496# 0
C1037 b[5] bitslice\[5\].u_fa/a_2012_472# 0.02435f
C1038 b[10] bitslice\[10\].u_fa/a_1072_156# 0.0302f
C1039 a[10] bitslice\[10\].u_fa/a_2012_472# 0.01748f
C1040 bitslice\[11\].u_fa/CI bitslice\[10\].u_fa/a_952_112# 0.11504f
C1041 VPWR bitslice\[20\].u_fa/a_680_496# 0.00283f
C1042 a[21] FILLER_21_2/a_484_472# 0.01259f
C1043 u_msb_x3/a_728_93# u_msb_x3/a_718_524# 0.33141f
C1044 a[2] bitslice\[2\].u_fa/a_2012_472# 0.01748f
C1045 FILLER_21_2/a_36_472# u_msb_x3/a_728_93# 0
C1046 s[0] bitslice\[0\].u_fa/a_680_156# 0
C1047 b[6] bitslice\[5\].u_fa/CI 0
C1048 a[21] bitslice\[19\].u_fa/a_512_496# 0
C1049 bitslice\[18\].u_fa/a_2012_472# b[18] 0.02435f
C1050 a[20] bitslice\[20\].u_fa/a_512_496# 0
C1051 bitslice\[2\].u_fa/a_1072_156# bitslice\[2\].u_fa/a_1992_156# 0.00753f
C1052 bitslice\[7\].u_fa/CI b[8] 0
C1053 bitslice\[8\].u_fa/a_3048_156# bitslice\[8\].u_fa/CI 0.00123f
C1054 VPWR bitslice\[15\].u_fa/a_2012_472# 0.29058f
C1055 a[2] bitslice\[2\].u_fa/a_512_496# 0
C1056 a[6] b[7] 0
C1057 VPWR bitslice\[1\].u_fa/a_512_496# 0.00292f
C1058 VPWR bitslice\[10\].u_fa/a_124_46# 0.46952f
C1059 bitslice\[20\].u_fa/a_124_46# bitslice\[20\].u_fa/a_1072_156# 0.0288f
C1060 VPWR bitslice\[12\].u_fa/a_680_156# 0
C1061 bitslice\[1\].u_fa/a_1072_496# bitslice\[1\].u_fa/a_512_496# 0
C1062 bitslice\[8\].u_fa/a_952_112# bitslice\[8\].u_fa/a_1072_156# 0.00934f
C1063 bitslice\[2\].u_fa/a_952_112# bitslice\[2\].u_fa/a_124_46# 0.01486f
C1064 bitslice\[18\].u_fa/CI bitslice\[18\].u_fa/a_3028_472# 0
C1065 bitslice\[10\].u_fa/a_512_496# bitslice\[10\].u_fa/a_124_46# 0.00639f
C1066 bitslice\[13\].u_fa/a_124_46# b[13] 0.05484f
C1067 bitslice\[9\].u_fa/a_3028_472# bitslice\[9\].u_fa/CI 0.00236f
C1068 bitslice\[20\].u_fa/CI a[21] 0.01474f
C1069 bitslice\[20\].u_fa/CI bitslice\[20\].u_fa/a_1992_156# 0.70111f
C1070 a[12] bitslice\[12\].u_fa/a_952_112# 0.17729f
C1071 s[12] bitslice\[12\].u_fa/a_680_496# 0
C1072 b[12] bitslice\[12\].u_fa/a_1072_496# 0.02505f
C1073 bitslice\[3\].u_fa/CI bitslice\[2\].u_fa/CI 0.06088f
C1074 b[6] bitslice\[9\].u_fa/CI 0
C1075 b[9] bitslice\[9\].u_fa/a_952_112# 0.77859f
C1076 bitslice\[9\].u_fa/a_2012_472# a[9] 0.01751f
C1077 s[9] bitslice\[9\].u_fa/a_512_156# 0.00108f
C1078 bitslice\[3\].u_fa/a_512_496# VPWR 0.00292f
C1079 bitslice\[9\].u_fa/a_124_46# VPWR 0.46957f
C1080 bitslice\[19\].u_fa/a_1072_156# bitslice\[19\].u_fa/a_124_46# 0.0288f
C1081 bitslice\[5\].u_fa/a_1992_156# a[5] 0.03757f
C1082 bitslice\[2\].u_fa/a_680_156# VPWR 0
C1083 bitslice\[2\].u_fa/a_124_46# b[3] 0
C1084 bitslice\[6\].u_fa/a_124_46# b[7] 0
C1085 bitslice\[20\].u_fa/a_3048_156# bitslice\[18\].u_fa/CI 0
C1086 u_msb_x3/a_56_524# bitslice\[20\].u_fa/CI 0.00337f
C1087 VPWR bitslice\[18\].u_fa/a_680_496# 0.00283f
C1088 bitslice\[16\].u_fa/CI bitslice\[15\].u_fa/a_952_112# 0.1229f
C1089 VPWR a[3] 0.76087f
C1090 VPWR bitslice\[14\].u_fa/a_124_46# 0.46952f
C1091 a[8] s[7] 0.19959f
C1092 bitslice\[18\].u_fa/CI bitslice\[16\].u_fa/a_3028_472# 0
C1093 bitslice\[10\].u_fa/a_512_156# s[10] 0
C1094 b[11] bitslice\[9\].u_fa/CO 0.00269f
C1095 bitslice\[3\].u_fa/a_680_496# VPWR 0.00283f
C1096 a[21] bitslice\[19\].u_fa/a_1072_156# 0.00113f
C1097 bitslice\[4\].u_fa/CI bitslice\[3\].u_fa/a_3028_472# 0
C1098 bitslice\[20\].u_fa/a_1072_156# b[20] 0.0302f
C1099 bitslice\[16\].u_fa/CI a[17] 0.00113f
C1100 b[11] bitslice\[11\].u_fa/a_1072_496# 0.02505f
C1101 bitslice\[7\].u_fa/a_1992_156# bitslice\[7\].u_fa/a_1072_156# 0.00753f
C1102 s[7] bitslice\[7\].u_fa/a_680_156# 0
C1103 b[5] a[4] 0
C1104 VPWR bitslice\[3\].u_fa/a_1072_156# 0.01572f
C1105 bitslice\[18\].u_fa/a_3028_472# bitslice\[18\].u_fa/a_952_112# 0.00197f
C1106 VPWR bitslice\[16\].u_fa/a_512_496# 0.00292f
C1107 bitslice\[9\].u_fa/CO s[10] 0.00205f
C1108 bitslice\[3\].u_fa/a_1992_156# a[3] 0.03757f
C1109 b[6] bitslice\[6\].u_fa/a_1992_156# 0.03179f
C1110 bitslice\[14\].u_fa/a_1072_156# bitslice\[14\].u_fa/a_124_46# 0.0288f
C1111 a[0] bitslice\[1\].u_fa/a_952_112# 0
C1112 s[21] b[20] 0.00256f
C1113 bitslice\[7\].u_fa/a_680_496# bitslice\[7\].u_fa/a_124_46# 0.00655f
C1114 VPWR bitslice\[7\].u_fa/a_3028_472# 0.00593f
C1115 bitslice\[3\].u_fa/CI bitslice\[1\].u_fa/a_952_112# 0
C1116 bitslice\[14\].u_fa/a_680_496# s[14] 0
C1117 cin s[0] 0.00205f
C1118 s[17] bitslice\[17\].u_fa/CI 0.00239f
C1119 b[15] bitslice\[15\].u_fa/a_3028_472# 0.00428f
C1120 FILLER_21_2/a_572_375# u_msb_x3/a_728_93# 0.00347f
C1121 bitslice\[5\].u_fa/a_3028_472# VPWR 0.00593f
C1122 bitslice\[3\].u_fa/a_512_496# bitslice\[3\].u_fa/a_124_46# 0.00639f
C1123 a[9] bitslice\[8\].u_fa/a_124_46# 0.00783f
C1124 bitslice\[18\].u_fa/CI a[18] 0.22516f
C1125 VPWR a[12] 0.67821f
C1126 a[5] bitslice\[5\].u_fa/CI 0.2268f
C1127 bitslice\[5\].u_fa/a_1072_496# bitslice\[5\].u_fa/a_124_46# 0.0139f
C1128 bitslice\[3\].u_fa/a_680_156# s[3] 0
C1129 bitslice\[20\].u_fa/a_124_46# s[20] 0.26234f
C1130 b[20] u_msb_x3/a_1936_472# 0.00247f
C1131 bitslice\[3\].u_fa/a_1072_156# bitslice\[3\].u_fa/a_1992_156# 0.00753f
C1132 bitslice\[7\].u_fa/a_124_46# a[7] 0.60604f
C1133 a[6] bitslice\[6\].u_fa/a_512_496# 0
C1134 a[8] a[9] 0.04751f
C1135 bitslice\[20\].u_fa/CI bitslice\[19\].u_fa/CI 0.0903f
C1136 a[15] bitslice\[15\].u_fa/a_1072_496# 0.02208f
C1137 bitslice\[9\].u_fa/a_1072_496# bitslice\[9\].u_fa/a_512_496# 0
C1138 a[3] bitslice\[3\].u_fa/a_124_46# 0.60604f
C1139 b[20] bitslice\[20\].u_fa/a_2012_472# 0.02435f
C1140 s[8] bitslice\[8\].u_fa/a_512_496# 0.00137f
C1141 bitslice\[15\].u_fa/CI b[13] 0.00218f
C1142 bitslice\[8\].u_fa/a_1072_156# b[8] 0.0302f
C1143 bitslice\[9\].u_fa/CO bitslice\[7\].u_fa/a_952_112# 0
C1144 VPWR bitslice\[0\].u_fa/a_680_496# 0.00283f
C1145 bitslice\[4\].u_fa/a_3028_472# bitslice\[4\].u_fa/a_952_112# 0.00197f
C1146 bitslice\[3\].u_fa/a_680_496# bitslice\[3\].u_fa/a_124_46# 0.00655f
C1147 bitslice\[20\].u_fa/a_124_46# VPWR 0.46925f
C1148 u_msb_x3/A3 u_msb_x3/a_952_93# 0
C1149 b[21] u_msb_x3/a_728_93# 0.13154f
C1150 bitslice\[7\].u_fa/CI bitslice\[7\].u_fa/a_124_46# 0.27486f
C1151 bitslice\[9\].u_fa/CO bitslice\[10\].u_fa/a_3028_472# 0.00135f
C1152 bitslice\[20\].u_fa/a_3028_472# u_msb_x3/A3 0.00217f
C1153 bitslice\[16\].u_fa/a_2012_472# bitslice\[16\].u_fa/a_952_112# 0.7796f
C1154 bitslice\[16\].u_fa/a_1072_496# bitslice\[16\].u_fa/a_512_496# 0
C1155 b[4] bitslice\[5\].u_fa/CI 0.10396f
C1156 bitslice\[9\].u_fa/CI b[9] 0.36292f
C1157 bitslice\[13\].u_fa/a_3028_472# bitslice\[14\].u_fa/CI 0
C1158 bitslice\[5\].u_fa/a_1992_156# bitslice\[6\].u_fa/CI 0.001f
C1159 bitslice\[6\].u_fa/a_124_46# bitslice\[6\].u_fa/a_512_496# 0.00639f
C1160 s[4] bitslice\[4\].u_fa/a_512_156# 0
C1161 bitslice\[12\].u_fa/a_680_496# bitslice\[12\].u_fa/a_124_46# 0.00655f
C1162 u_msb_x3/a_244_524# b[21] 0
C1163 a[8] bitslice\[8\].u_fa/a_1992_156# 0.03766f
C1164 bitslice\[18\].u_fa/CI a[17] 0.01339f
C1165 b[20] s[20] 0.00338f
C1166 bitslice\[19\].u_fa/a_1072_156# bitslice\[19\].u_fa/CI 0.61608f
C1167 bitslice\[1\].u_fa/a_952_112# bitslice\[1\].u_fa/a_1072_156# 0.00934f
C1168 bitslice\[9\].u_fa/a_1992_156# bitslice\[9\].u_fa/a_1072_156# 0.00753f
C1169 s[9] bitslice\[9\].u_fa/a_952_112# 0.00189f
C1170 bitslice\[3\].u_fa/a_1072_156# bitslice\[3\].u_fa/a_124_46# 0.0288f
C1171 bitslice\[13\].u_fa/a_124_46# a[13] 0.60604f
C1172 cin b[1] 0
C1173 a[21] bitslice\[20\].u_fa/a_1072_496# 0.0041f
C1174 b[12] bitslice\[13\].u_fa/a_124_46# 0
C1175 s[1] s[2] 0.00743f
C1176 b[12] bitslice\[12\].u_fa/a_3028_472# 0.00428f
C1177 bitslice\[13\].u_fa/a_2012_472# bitslice\[13\].u_fa/a_952_112# 0.7796f
C1178 bitslice\[13\].u_fa/a_1072_496# bitslice\[13\].u_fa/a_680_496# 0
C1179 a[15] bitslice\[16\].u_fa/a_124_46# 0
C1180 a[18] bitslice\[18\].u_fa/a_952_112# 0.17729f
C1181 s[18] bitslice\[18\].u_fa/a_680_496# 0
C1182 bitslice\[11\].u_fa/CI b[10] 0.09026f
C1183 a[20] bitslice\[20\].u_fa/a_680_496# 0
C1184 bitslice\[17\].u_fa/a_124_46# bitslice\[16\].u_fa/a_124_46# 0.02943f
C1185 b[20] VPWR 2.16919f
C1186 bitslice\[11\].u_fa/a_3028_472# bitslice\[11\].u_fa/a_952_112# 0.00197f
C1187 bitslice\[11\].u_fa/a_680_156# bitslice\[11\].u_fa/a_124_46# 0.00316f
C1188 bitslice\[11\].u_fa/a_1072_496# bitslice\[11\].u_fa/a_680_496# 0
C1189 bitslice\[8\].u_fa/a_124_46# a[7] 0
C1190 b[19] b[20] 0.1159f
C1191 bitslice\[4\].u_fa/a_952_112# bitslice\[4\].u_fa/a_1072_496# 0.64312f
C1192 bitslice\[4\].u_fa/a_680_496# bitslice\[4\].u_fa/a_124_46# 0.00655f
C1193 bitslice\[15\].u_fa/a_952_112# bitslice\[15\].u_fa/a_1072_496# 0.64312f
C1194 bitslice\[9\].u_fa/a_124_46# bitslice\[9\].u_fa/a_1072_496# 0.0139f
C1195 bitslice\[20\].u_fa/a_952_112# bitslice\[19\].u_fa/a_952_112# 0.03505f
C1196 b[2] bitslice\[2\].u_fa/a_124_46# 0.05484f
C1197 a[8] a[7] 0.86295f
C1198 a[21] u_msb_x3/a_728_93# 0.50545f
C1199 a[16] bitslice\[15\].u_fa/a_124_46# 0.00806f
C1200 b[5] VPWR 1.90362f
C1201 b[16] bitslice\[16\].u_fa/a_1072_156# 0.0302f
C1202 bitslice\[18\].u_fa/CI bitslice\[19\].u_fa/CI 0.04741f
C1203 bitslice\[20\].u_fa/a_124_46# FILLER_21_2/a_124_375# 0.03012f
C1204 s[1] bitslice\[1\].u_fa/a_512_156# 0.00108f
C1205 bitslice\[11\].u_fa/a_512_496# a[11] 0.002f
C1206 b[19] bitslice\[19\].u_fa/a_1992_156# 0.03179f
C1207 a[16] bitslice\[16\].u_fa/a_2012_472# 0.01748f
C1208 b[10] bitslice\[10\].u_fa/a_952_112# 0.77989f
C1209 bitslice\[9\].u_fa/a_124_46# b[8] 0
C1210 u_msb_x3/a_244_524# a[21] 0.00529f
C1211 bitslice\[13\].u_fa/CI a[12] 0.01041f
C1212 bitslice\[6\].u_fa/a_3028_472# bitslice\[6\].u_fa/a_2012_472# 0
C1213 a[14] VPWR 0.67821f
C1214 u_msb_x3/a_56_524# u_msb_x3/a_728_93# 0.01674f
C1215 a[8] bitslice\[7\].u_fa/CI 0.00171f
C1216 bitslice\[9\].u_fa/a_1072_156# bitslice\[9\].u_fa/a_952_112# 0.00934f
C1217 bitslice\[13\].u_fa/a_1072_156# VPWR 0.01572f
C1218 bitslice\[2\].u_fa/CI bitslice\[2\].u_fa/a_1992_156# 0.70111f
C1219 bitslice\[6\].u_fa/CI bitslice\[5\].u_fa/CI 0.08597f
C1220 bitslice\[18\].u_fa/a_2012_472# bitslice\[18\].u_fa/a_3028_472# 0
C1221 a[0] bitslice\[0\].u_fa/a_952_112# 0.17729f
C1222 cin bitslice\[0\].u_fa/a_1992_156# 0.71612f
C1223 u_msb_x3/a_56_524# u_msb_x3/a_244_524# 0.00202f
C1224 bitslice\[17\].u_fa/CI b[15] 0.00218f
C1225 VPWR bitslice\[12\].u_fa/a_512_496# 0.00292f
C1226 b[16] bitslice\[16\].u_fa/CI 0.34555f
C1227 a[1] s[0] 0.20011f
C1228 a[10] a[9] 0.86295f
C1229 bitslice\[6\].u_fa/a_952_112# bitslice\[6\].u_fa/a_2012_472# 0.7796f
C1230 bitslice\[12\].u_fa/CI bitslice\[12\].u_fa/a_952_112# 2.42979f
C1231 bitslice\[6\].u_fa/CI bitslice\[9\].u_fa/CI 0
C1232 bitslice\[14\].u_fa/a_952_112# a[15] 0
C1233 bitslice\[16\].u_fa/a_124_46# a[17] 0.00783f
C1234 bitslice\[5\].u_fa/a_2012_472# a[5] 0.01751f
C1235 bitslice\[1\].u_fa/a_3028_472# bitslice\[2\].u_fa/CI 0
C1236 bitslice\[5\].u_fa/a_1072_496# bitslice\[5\].u_fa/a_680_496# 0
C1237 bitslice\[3\].u_fa/CI s[3] 0.00239f
C1238 bitslice\[14\].u_fa/a_1072_156# a[14] 0.03894f
C1239 bitslice\[8\].u_fa/a_2012_472# bitslice\[9\].u_fa/CI 0.00269f
C1240 a[19] s[19] 0.1788f
C1241 bitslice\[11\].u_fa/a_952_112# s[11] 0.00139f
C1242 a[11] bitslice\[11\].u_fa/a_1072_156# 0.03679f
C1243 bitslice\[15\].u_fa/a_3048_156# bitslice\[15\].u_fa/a_952_112# 0.00316f
C1244 VPWR bitslice\[3\].u_fa/a_680_156# 0
C1245 bitslice\[19\].u_fa/CI bitslice\[18\].u_fa/a_952_112# 0.11464f
C1246 VPWR bitslice\[6\].u_fa/a_3028_472# 0.00593f
C1247 bitslice\[0\].u_fa/a_512_496# bitslice\[0\].u_fa/a_1072_496# 0
C1248 bitslice\[17\].u_fa/CI b[18] 0.00612f
C1249 bitslice\[15\].u_fa/CI bitslice\[15\].u_fa/a_1992_156# 0.69584f
C1250 bitslice\[3\].u_fa/a_1072_496# bitslice\[3\].u_fa/a_2012_472# 0.00406f
C1251 s[21] u_msb_x3/a_1524_472# 0
C1252 bitslice\[0\].u_fa/a_952_112# bitslice\[0\].u_fa/a_3028_472# 0.00197f
C1253 s[9] bitslice\[9\].u_fa/CI 0.00272f
C1254 b[13] a[13] 0.46296f
C1255 bitslice\[0\].u_fa/a_512_156# VPWR 0
C1256 bitslice\[3\].u_fa/CI a[4] 0.00171f
C1257 b[12] b[13] 0.83145f
C1258 s[7] bitslice\[7\].u_fa/a_680_496# 0
C1259 b[7] bitslice\[7\].u_fa/a_1072_496# 0.02505f
C1260 b[14] VPWR 1.90361f
C1261 VPWR bitslice\[8\].u_fa/CI 0.72747f
C1262 bitslice\[17\].u_fa/a_1072_496# bitslice\[17\].u_fa/a_952_112# 0.64312f
C1263 bitslice\[2\].u_fa/a_952_112# bitslice\[2\].u_fa/a_1072_156# 0.00934f
C1264 bitslice\[3\].u_fa/a_1072_496# bitslice\[3\].u_fa/a_952_112# 0.64312f
C1265 bitslice\[14\].u_fa/a_680_496# bitslice\[14\].u_fa/a_124_46# 0.00655f
C1266 bitslice\[19\].u_fa/a_512_156# bitslice\[19\].u_fa/a_124_46# 0.00257f
C1267 bitslice\[19\].u_fa/a_1072_496# bitslice\[19\].u_fa/a_512_496# 0
C1268 bitslice\[19\].u_fa/a_3028_472# bitslice\[19\].u_fa/a_952_112# 0.00197f
C1269 bitslice\[9\].u_fa/CI bitslice\[7\].u_fa/a_952_112# 0.00219f
C1270 bitslice\[6\].u_fa/a_952_112# VPWR 0.59588f
C1271 a[14] bitslice\[14\].u_fa/a_2012_472# 0.01748f
C1272 a[1] b[1] 0.46296f
C1273 bitslice\[0\].u_fa/a_2012_472# b[0] 0.02435f
C1274 bitslice\[5\].u_fa/a_1992_156# bitslice\[5\].u_fa/a_1072_156# 0.00753f
C1275 cin a[2] 0
C1276 a[10] bitslice\[10\].u_fa/a_680_156# 0
C1277 s[21] u_msb_x3/A3 0.26675f
C1278 VPWR bitslice\[13\].u_fa/a_1072_496# 0.28074f
C1279 s[7] a[7] 0.19269f
C1280 bitslice\[3\].u_fa/a_952_112# a[2] 0
C1281 bitslice\[10\].u_fa/a_3028_472# bitslice\[9\].u_fa/CI 0
C1282 b[6] bitslice\[6\].u_fa/a_2012_472# 0.02435f
C1283 bitslice\[6\].u_fa/CI bitslice\[6\].u_fa/a_1992_156# 0.70111f
C1284 a[14] s[15] 0
C1285 a[4] bitslice\[4\].u_fa/a_124_46# 0.60698f
C1286 bitslice\[14\].u_fa/a_952_112# bitslice\[15\].u_fa/a_952_112# 0.02943f
C1287 bitslice\[17\].u_fa/a_680_156# bitslice\[17\].u_fa/a_124_46# 0.00316f
C1288 a[6] bitslice\[5\].u_fa/CI 0.00171f
C1289 a[21] bitslice\[19\].u_fa/a_512_156# 0
C1290 bitslice\[18\].u_fa/a_2012_472# a[18] 0.01748f
C1291 u_msb_x3/a_1936_472# u_msb_x3/A3 0.02562f
C1292 bitslice\[20\].u_fa/a_124_46# a[20] 0.60698f
C1293 bitslice\[13\].u_fa/a_1072_156# bitslice\[13\].u_fa/CI 0.61608f
C1294 VPWR bitslice\[10\].u_fa/a_680_496# 0.00283f
C1295 bitslice\[14\].u_fa/a_1072_156# b[14] 0.0302f
C1296 bitslice\[7\].u_fa/CI s[7] 0.00345f
C1297 bitslice\[18\].u_fa/CI b[16] 0.00474f
C1298 bitslice\[20\].u_fa/a_2012_472# u_msb_x3/A3 0.01771f
C1299 bitslice\[1\].u_fa/a_512_156# bitslice\[1\].u_fa/a_124_46# 0.00257f
C1300 bitslice\[1\].u_fa/a_3028_472# bitslice\[1\].u_fa/a_952_112# 0.00197f
C1301 bitslice\[18\].u_fa/CI bitslice\[18\].u_fa/a_1072_156# 0.61667f
C1302 VPWR bitslice\[12\].u_fa/CI 0.72367f
C1303 bitslice\[3\].u_fa/a_952_112# bitslice\[3\].u_fa/a_2012_472# 0.7796f
C1304 bitslice\[8\].u_fa/a_1072_156# bitslice\[8\].u_fa/a_124_46# 0.0288f
C1305 bitslice\[2\].u_fa/a_952_112# s[2] 0.00117f
C1306 bitslice\[10\].u_fa/a_1072_496# bitslice\[10\].u_fa/a_952_112# 0.64312f
C1307 a[12] bitslice\[12\].u_fa/a_1072_496# 0.01952f
C1308 bitslice\[11\].u_fa/a_952_112# bitslice\[11\].u_fa/CI 2.44171f
C1309 bitslice\[9\].u_fa/a_1072_156# bitslice\[9\].u_fa/CI 0.61608f
C1310 a[4] a[5] 0.04751f
C1311 a[6] bitslice\[9\].u_fa/CI 0
C1312 a[8] bitslice\[8\].u_fa/a_1072_156# 0.03894f
C1313 bitslice\[3\].u_fa/a_680_156# bitslice\[3\].u_fa/a_124_46# 0.00316f
C1314 bitslice\[8\].u_fa/a_952_112# bitslice\[8\].u_fa/CI 2.43003f
C1315 bitslice\[3\].u_fa/a_952_112# bitslice\[4\].u_fa/a_952_112# 0.03505f
C1316 a[11] a[10] 0.04751f
C1317 bitslice\[18\].u_fa/a_680_156# bitslice\[18\].u_fa/a_124_46# 0.00316f
C1318 VPWR bitslice\[9\].u_fa/a_3028_472# 0.00593f
C1319 u_msb_x3/a_1524_472# VPWR 0
C1320 a[19] bitslice\[17\].u_fa/CI 0
C1321 a[19] b[18] 0
C1322 bitslice\[14\].u_fa/a_3028_472# bitslice\[14\].u_fa/a_952_112# 0.00197f
C1323 VPWR bitslice\[17\].u_fa/a_512_156# 0
C1324 bitslice\[19\].u_fa/CI bitslice\[18\].u_fa/a_3048_156# 0
C1325 VPWR b[6] 1.90357f
C1326 VPWR bitslice\[11\].u_fa/a_124_46# 0.46957f
C1327 bitslice\[15\].u_fa/CI bitslice\[14\].u_fa/a_3048_156# 0
C1328 u_msb_x3/a_2215_68# u_msb_x3/a_728_93# 0
C1329 bitslice\[11\].u_fa/a_952_112# bitslice\[10\].u_fa/a_952_112# 0.02943f
C1330 s[4] bitslice\[4\].u_fa/a_512_496# 0.00137f
C1331 a[20] b[20] 0.46601f
C1332 b[14] bitslice\[14\].u_fa/a_2012_472# 0.02435f
C1333 a[4] b[4] 0.46601f
C1334 bitslice\[5\].u_fa/a_1072_156# bitslice\[5\].u_fa/CI 0.61608f
C1335 bitslice\[5\].u_fa/CI bitslice\[5\].u_fa/a_952_112# 2.44024f
C1336 VPWR bitslice\[15\].u_fa/a_124_46# 0.46957f
C1337 bitslice\[15\].u_fa/a_512_156# bitslice\[15\].u_fa/a_124_46# 0.00257f
C1338 VPWR u_msb_x3/A3 0.87116f
C1339 VPWR bitslice\[16\].u_fa/a_2012_472# 0.29058f
C1340 b[19] u_msb_x3/A3 0.00667f
C1341 bitslice\[18\].u_fa/a_1072_156# bitslice\[18\].u_fa/a_952_112# 0.00934f
C1342 s[17] bitslice\[17\].u_fa/a_124_46# 0.26222f
C1343 bitslice\[17\].u_fa/a_1072_156# bitslice\[17\].u_fa/a_952_112# 0.00934f
C1344 a[6] bitslice\[6\].u_fa/a_1992_156# 0.03766f
C1345 a[0] VPWR 0.67121f
C1346 bitslice\[13\].u_fa/a_1072_496# bitslice\[13\].u_fa/CI 0.00463f
C1347 bitslice\[9\].u_fa/a_124_46# bitslice\[8\].u_fa/a_124_46# 0.02943f
C1348 bitslice\[7\].u_fa/a_2012_472# bitslice\[7\].u_fa/a_952_112# 0.7796f
C1349 bitslice\[7\].u_fa/a_1072_496# bitslice\[7\].u_fa/a_512_496# 0
C1350 bitslice\[18\].u_fa/a_2012_472# bitslice\[19\].u_fa/CI 0
C1351 bitslice\[3\].u_fa/CI VPWR 0.93267f
C1352 VPWR bitslice\[13\].u_fa/a_512_496# 0.00292f
C1353 bitslice\[14\].u_fa/a_124_46# bitslice\[13\].u_fa/a_124_46# 0.01624f
C1354 bitslice\[0\].u_fa/a_952_112# bitslice\[0\].u_fa/a_124_46# 0.01486f
C1355 s[17] a[18] 0.19959f
C1356 bitslice\[18\].u_fa/CI bitslice\[18\].u_fa/a_1072_496# 0.00434f
C1357 a[8] bitslice\[9\].u_fa/a_124_46# 0
C1358 bitslice\[14\].u_fa/a_952_112# bitslice\[14\].u_fa/CI 2.38572f
C1359 s[1] bitslice\[1\].u_fa/a_952_112# 0.00139f
C1360 b[12] a[13] 0
C1361 b[16] bitslice\[16\].u_fa/a_124_46# 0.05484f
C1362 bitslice\[7\].u_fa/a_680_496# a[7] 0.00136f
C1363 bitslice\[12\].u_fa/CI bitslice\[13\].u_fa/CI 0.06088f
C1364 a[2] a[1] 0.86295f
C1365 a[0] bitslice\[1\].u_fa/CI 0.01153f
C1366 VPWR bitslice\[4\].u_fa/a_124_46# 0.46952f
C1367 bitslice\[3\].u_fa/CI bitslice\[3\].u_fa/a_1992_156# 0.69584f
C1368 VPWR bitslice\[0\].u_fa/a_3028_472# 0.00593f
C1369 bitslice\[16\].u_fa/a_952_112# bitslice\[16\].u_fa/a_1072_156# 0.00934f
C1370 bitslice\[4\].u_fa/a_1072_156# bitslice\[4\].u_fa/a_952_112# 0.00934f
C1371 s[19] bitslice\[19\].u_fa/a_124_46# 0.26222f
C1372 bitslice\[4\].u_fa/CI bitslice\[4\].u_fa/a_2012_472# 0.00394f
C1373 FILLER_21_2/a_124_375# u_msb_x3/A3 0
C1374 bitslice\[9\].u_fa/CO bitslice\[10\].u_fa/a_1072_156# 0.61603f
C1375 bitslice\[16\].u_fa/a_2012_472# bitslice\[16\].u_fa/a_1072_496# 0.00406f
C1376 b[11] bitslice\[12\].u_fa/a_952_112# 0.0025f
C1377 bitslice\[12\].u_fa/a_2012_472# bitslice\[12\].u_fa/a_952_112# 0.7796f
C1378 bitslice\[12\].u_fa/a_1072_496# bitslice\[12\].u_fa/a_512_496# 0
C1379 bitslice\[6\].u_fa/a_2012_472# bitslice\[6\].u_fa/a_1072_496# 0.00406f
C1380 s[17] a[17] 0.1788f
C1381 a[14] bitslice\[14\].u_fa/a_680_496# 0
C1382 VPWR a[5] 0.76087f
C1383 bitslice\[8\].u_fa/CI b[8] 0.34553f
C1384 b[2] bitslice\[2\].u_fa/a_1072_156# 0.0302f
C1385 VPWR bitslice\[1\].u_fa/a_1072_156# 0.01572f
C1386 bitslice\[14\].u_fa/a_1072_496# bitslice\[14\].u_fa/CI 0.00434f
C1387 bitslice\[7\].u_fa/CI a[7] 0.22669f
C1388 cin a[1] 0
C1389 bitslice\[18\].u_fa/a_1072_496# bitslice\[18\].u_fa/a_952_112# 0.64312f
C1390 VPWR bitslice\[17\].u_fa/a_512_496# 0.00292f
C1391 s[15] bitslice\[15\].u_fa/a_124_46# 0.26222f
C1392 a[21] bitslice\[20\].u_fa/a_512_156# 0
C1393 VPWR b[9] 1.90592f
C1394 s[14] a[13] 0
C1395 a[12] bitslice\[13\].u_fa/a_124_46# 0
C1396 s[19] a[18] 0
C1397 bitslice\[15\].u_fa/a_3028_472# bitslice\[15\].u_fa/a_952_112# 0.00197f
C1398 bitslice\[17\].u_fa/CI bitslice\[18\].u_fa/a_3028_472# 0
C1399 b[18] bitslice\[18\].u_fa/a_3028_472# 0.00428f
C1400 bitslice\[16\].u_fa/CI bitslice\[16\].u_fa/a_952_112# 2.42979f
C1401 bitslice\[1\].u_fa/CI bitslice\[0\].u_fa/a_3028_472# 0.00124f
C1402 bitslice\[14\].u_fa/a_512_156# s[14] 0
C1403 bitslice\[11\].u_fa/a_3028_472# bitslice\[9\].u_fa/CO 0
C1404 bitslice\[0\].u_fa/a_680_496# s[0] 0
C1405 b[0] bitslice\[0\].u_fa/a_1072_496# 0.02505f
C1406 bitslice\[15\].u_fa/CI bitslice\[15\].u_fa/a_2012_472# 0.00772f
C1407 bitslice\[3\].u_fa/CI bitslice\[3\].u_fa/a_124_46# 0.27486f
C1408 bitslice\[20\].u_fa/CI u_msb_x3/a_952_93# 0
C1409 VPWR bitslice\[14\].u_fa/a_680_156# 0
C1410 bitslice\[20\].u_fa/CI bitslice\[20\].u_fa/a_3028_472# 0.00135f
C1411 VPWR b[4] 1.90284f
C1412 a[19] bitslice\[19\].u_fa/a_2012_472# 0.01751f
C1413 b[17] bitslice\[16\].u_fa/CI 0.00269f
C1414 bitslice\[13\].u_fa/a_680_496# s[13] 0
C1415 bitslice\[7\].u_fa/a_1072_156# bitslice\[7\].u_fa/a_952_112# 0.00934f
C1416 bitslice\[1\].u_fa/CI bitslice\[1\].u_fa/a_1072_156# 0.61608f
C1417 b[2] s[2] 0.00338f
C1418 bitslice\[8\].u_fa/a_3028_472# bitslice\[8\].u_fa/CI 0.00135f
C1419 bitslice\[2\].u_fa/a_952_112# bitslice\[2\].u_fa/CI 2.42979f
C1420 bitslice\[18\].u_fa/CI bitslice\[18\].u_fa/a_124_46# 0.27486f
C1421 a[16] bitslice\[16\].u_fa/a_1072_156# 0.03894f
C1422 a[15] b[15] 0.46296f
C1423 bitslice\[11\].u_fa/a_2012_472# a[11] 0.01751f
C1424 bitslice\[4\].u_fa/a_124_46# bitslice\[3\].u_fa/a_124_46# 0.01624f
C1425 a[16] bitslice\[16\].u_fa/a_512_156# 0
C1426 VPWR bitslice\[6\].u_fa/a_1072_496# 0.28074f
C1427 s[5] bitslice\[5\].u_fa/a_124_46# 0.26222f
C1428 bitslice\[17\].u_fa/CI bitslice\[16\].u_fa/a_3028_472# 0.00124f
C1429 bitslice\[5\].u_fa/a_2012_472# bitslice\[5\].u_fa/a_952_112# 0.7796f
C1430 a[10] bitslice\[10\].u_fa/a_124_46# 0.60698f
C1431 b[10] bitslice\[10\].u_fa/a_1072_496# 0.02505f
C1432 bitslice\[6\].u_fa/CI bitslice\[6\].u_fa/a_2012_472# 0.00394f
C1433 bitslice\[0\].u_fa/a_2012_472# bitslice\[0\].u_fa/a_1072_496# 0.00406f
C1434 bitslice\[2\].u_fa/CI b[3] 0.00269f
C1435 bitslice\[19\].u_fa/a_3048_156# bitslice\[19\].u_fa/a_952_112# 0.00316f
C1436 bitslice\[9\].u_fa/a_124_46# a[10] 0.00806f
C1437 a[9] bitslice\[9\].u_fa/a_512_496# 0.002f
C1438 bitslice\[8\].u_fa/a_952_112# b[9] 0
C1439 bitslice\[16\].u_fa/CI bitslice\[17\].u_fa/a_3028_472# 0
C1440 b[18] bitslice\[19\].u_fa/a_124_46# 0
C1441 a[16] bitslice\[16\].u_fa/CI 0.22372f
C1442 bitslice\[1\].u_fa/a_952_112# bitslice\[1\].u_fa/a_124_46# 0.01486f
C1443 VPWR bitslice\[12\].u_fa/a_2012_472# 0.29058f
C1444 VPWR b[11] 1.90176f
C1445 s[5] s[6] 0.00743f
C1446 b[3] bitslice\[5\].u_fa/CI 0.00218f
C1447 bitslice\[11\].u_fa/a_952_112# b[10] 0.00248f
C1448 bitslice\[17\].u_fa/CI bitslice\[17\].u_fa/a_124_46# 0.27486f
C1449 bitslice\[11\].u_fa/a_1992_156# bitslice\[11\].u_fa/a_1072_156# 0.00753f
C1450 bitslice\[8\].u_fa/a_1992_156# bitslice\[8\].u_fa/a_1072_156# 0.00753f
C1451 bitslice\[12\].u_fa/CI bitslice\[12\].u_fa/a_1072_496# 0.00434f
C1452 bitslice\[3\].u_fa/a_512_496# bitslice\[3\].u_fa/a_1072_496# 0
C1453 a[4] bitslice\[4\].u_fa/a_512_156# 0
C1454 bitslice\[9\].u_fa/CI bitslice\[8\].u_fa/a_1072_496# 0
C1455 bitslice\[18\].u_fa/a_952_112# bitslice\[18\].u_fa/a_124_46# 0.01486f
C1456 bitslice\[11\].u_fa/a_1072_496# s[11] 0
C1457 b[15] bitslice\[15\].u_fa/a_952_112# 0.77779f
C1458 a[20] u_msb_x3/A3 0.02259f
C1459 VPWR s[10] 0.34826f
C1460 s[19] bitslice\[19\].u_fa/CI 0.00239f
C1461 bitslice\[13\].u_fa/CI bitslice\[13\].u_fa/a_1992_156# 0.69584f
C1462 bitslice\[17\].u_fa/CI a[18] 0.00558f
C1463 a[18] b[18] 0.46601f
C1464 VPWR bitslice\[6\].u_fa/CI 0.7245f
C1465 bitslice\[3\].u_fa/a_1072_496# a[3] 0.02208f
C1466 bitslice\[2\].u_fa/a_952_112# bitslice\[1\].u_fa/a_952_112# 0.03505f
C1467 bitslice\[10\].u_fa/a_124_46# a[9] 0
C1468 a[14] bitslice\[13\].u_fa/a_124_46# 0.00806f
C1469 bitslice\[18\].u_fa/CI bitslice\[16\].u_fa/a_952_112# 0.00148f
C1470 bitslice\[10\].u_fa/a_512_496# s[10] 0.00137f
C1471 bitslice\[14\].u_fa/CI bitslice\[15\].u_fa/a_3028_472# 0
C1472 bitslice\[0\].u_fa/a_124_46# VPWR 0.46952f
C1473 a[2] bitslice\[2\].u_fa/a_680_156# 0
C1474 b[20] bitslice\[19\].u_fa/a_952_112# 0.00242f
C1475 bitslice\[3\].u_fa/a_1072_496# bitslice\[3\].u_fa/a_680_496# 0
C1476 a[2] a[3] 0.04751f
C1477 bitslice\[8\].u_fa/a_2012_472# VPWR 0.29058f
C1478 bitslice\[13\].u_fa/a_1072_156# bitslice\[13\].u_fa/a_124_46# 0.0288f
C1479 a[12] b[13] 0
C1480 bitslice\[5\].u_fa/a_1072_496# bitslice\[5\].u_fa/CI 0.00463f
C1481 bitslice\[20\].u_fa/a_124_46# bitslice\[20\].u_fa/a_680_156# 0.00316f
C1482 b[17] bitslice\[18\].u_fa/CI 0.10122f
C1483 bitslice\[9\].u_fa/a_124_46# a[9] 0.60604f
C1484 a[4] bitslice\[5\].u_fa/a_952_112# 0
C1485 bitslice\[17\].u_fa/CI bitslice\[15\].u_fa/a_952_112# 0
C1486 VPWR s[9] 0.2911f
C1487 a[3] bitslice\[3\].u_fa/a_2012_472# 0.01751f
C1488 bitslice\[6\].u_fa/a_1992_156# bitslice\[6\].u_fa/a_1072_156# 0.00753f
C1489 a[6] bitslice\[6\].u_fa/a_2012_472# 0.01748f
C1490 s[6] bitslice\[6\].u_fa/a_512_156# 0
C1491 b[21] u_msb_x3/a_718_524# 0.02744f
C1492 bitslice\[20\].u_fa/a_1072_156# bitslice\[20\].u_fa/CI 0.61603f
C1493 bitslice\[18\].u_fa/a_1072_496# bitslice\[18\].u_fa/a_2012_472# 0.00406f
C1494 bitslice\[17\].u_fa/CI a[17] 0.22669f
C1495 s[21] FILLER_21_2/a_484_472# 0.01994f
C1496 VPWR bitslice\[7\].u_fa/a_952_112# 0.59588f
C1497 bitslice\[0\].u_fa/a_512_156# s[0] 0
C1498 VPWR bitslice\[15\].u_fa/a_680_156# 0
C1499 bitslice\[3\].u_fa/a_952_112# a[3] 0.17786f
C1500 a[19] bitslice\[19\].u_fa/a_124_46# 0.60604f
C1501 VPWR s[13] 0.29039f
C1502 VPWR bitslice\[1\].u_fa/a_3028_472# 0.00593f
C1503 VPWR bitslice\[10\].u_fa/a_3028_472# 0.00593f
C1504 b[9] bitslice\[9\].u_fa/a_1072_496# 0.02505f
C1505 bitslice\[18\].u_fa/CI bitslice\[17\].u_fa/a_3028_472# 0
C1506 bitslice\[9\].u_fa/CO bitslice\[11\].u_fa/CI 0.06088f
C1507 bitslice\[18\].u_fa/CI a[16] 0.00112f
C1508 bitslice\[10\].u_fa/a_680_156# bitslice\[10\].u_fa/a_124_46# 0.00316f
C1509 bitslice\[11\].u_fa/a_1072_496# bitslice\[11\].u_fa/CI 0.00463f
C1510 bitslice\[9\].u_fa/a_3028_472# bitslice\[9\].u_fa/a_2012_472# 0
C1511 bitslice\[12\].u_fa/CI bitslice\[12\].u_fa/a_3048_156# 0.00123f
C1512 b[11] bitslice\[13\].u_fa/CI 0.00218f
C1513 bitslice\[13\].u_fa/CI bitslice\[12\].u_fa/a_2012_472# 0
C1514 s[12] bitslice\[12\].u_fa/a_512_156# 0
C1515 bitslice\[2\].u_fa/a_3028_472# bitslice\[2\].u_fa/CI 0.00135f
C1516 bitslice\[8\].u_fa/a_952_112# bitslice\[8\].u_fa/a_2012_472# 0.7796f
C1517 b[9] b[8] 0.80907f
C1518 b[17] bitslice\[18\].u_fa/a_952_112# 0.00136f
C1519 a[19] a[21] 0.00266f
C1520 s[5] bitslice\[5\].u_fa/a_680_496# 0
C1521 bitslice\[8\].u_fa/a_124_46# bitslice\[8\].u_fa/CI 0.27486f
C1522 b[6] bitslice\[7\].u_fa/a_124_46# 0
C1523 VPWR bitslice\[9\].u_fa/a_1072_156# 0.01572f
C1524 VPWR bitslice\[18\].u_fa/a_680_156# 0
C1525 a[19] a[18] 0.04751f
C1526 bitslice\[3\].u_fa/a_952_112# bitslice\[3\].u_fa/a_1072_156# 0.00934f
C1527 u_msb_x3/a_952_93# u_msb_x3/a_728_93# 0.00421f
C1528 bitslice\[2\].u_fa/a_680_496# bitslice\[2\].u_fa/a_124_46# 0.00655f
C1529 bitslice\[14\].u_fa/a_124_46# a[13] 0
C1530 bitslice\[17\].u_fa/CI bitslice\[19\].u_fa/CI 0.01814f
C1531 bitslice\[19\].u_fa/CI b[18] 0.09066f
C1532 VPWR a[6] 0.67821f
C1533 VPWR bitslice\[11\].u_fa/a_680_496# 0.00283f
C1534 a[21] u_msb_x3/a_718_524# 0.13995f
C1535 bitslice\[13\].u_fa/a_1072_496# bitslice\[13\].u_fa/a_124_46# 0.0139f
C1536 bitslice\[1\].u_fa/CI bitslice\[1\].u_fa/a_3028_472# 0.00336f
C1537 bitslice\[17\].u_fa/a_1072_496# bitslice\[17\].u_fa/a_680_496# 0
C1538 bitslice\[9\].u_fa/CO bitslice\[10\].u_fa/a_952_112# 2.42979f
C1539 bitslice\[14\].u_fa/a_512_156# bitslice\[14\].u_fa/a_124_46# 0.00257f
C1540 a[8] bitslice\[8\].u_fa/CI 0.22372f
C1541 s[8] bitslice\[8\].u_fa/a_680_156# 0
C1542 bitslice\[14\].u_fa/CI b[15] 0.00203f
C1543 bitslice\[16\].u_fa/a_952_112# bitslice\[16\].u_fa/a_124_46# 0.01486f
C1544 FILLER_21_2/a_36_472# a[21] 0.01301f
C1545 bitslice\[4\].u_fa/CI s[4] 0.00205f
C1546 b[2] bitslice\[2\].u_fa/CI 0.34555f
C1547 bitslice\[11\].u_fa/CI bitslice\[9\].u_fa/a_952_112# 0
C1548 bitslice\[20\].u_fa/CI bitslice\[20\].u_fa/a_2012_472# 0.00394f
C1549 bitslice\[8\].u_fa/a_952_112# bitslice\[7\].u_fa/a_952_112# 0.03505f
C1550 bitslice\[3\].u_fa/CI bitslice\[2\].u_fa/a_2012_472# 0
C1551 b[17] bitslice\[16\].u_fa/a_124_46# 0
C1552 VPWR bitslice\[16\].u_fa/a_1072_156# 0.01572f
C1553 u_msb_x3/a_56_524# u_msb_x3/a_718_524# 0.0092f
C1554 VPWR bitslice\[4\].u_fa/a_512_156# 0
C1555 bitslice\[15\].u_fa/CI a[14] 0.01153f
C1556 a[11] bitslice\[10\].u_fa/a_124_46# 0.00783f
C1557 bitslice\[16\].u_fa/a_512_156# VPWR 0
C1558 bitslice\[12\].u_fa/a_1072_156# bitslice\[12\].u_fa/a_1992_156# 0.00753f
C1559 bitslice\[12\].u_fa/CI bitslice\[12\].u_fa/a_3028_472# 0.00135f
C1560 bitslice\[6\].u_fa/a_124_46# VPWR 0.46952f
C1561 b[16] bitslice\[16\].u_fa/a_1992_156# 0.03179f
C1562 VPWR bitslice\[11\].u_fa/a_512_156# 0
C1563 bitslice\[13\].u_fa/a_1072_156# b[13] 0.0302f
C1564 a[21] bitslice\[19\].u_fa/a_2012_472# 0
C1565 bitslice\[7\].u_fa/CI bitslice\[6\].u_fa/a_3048_156# 0
C1566 bitslice\[11\].u_fa/a_512_496# bitslice\[11\].u_fa/a_124_46# 0.00639f
C1567 VPWR FILLER_21_2/a_484_472# 0.23287f
C1568 bitslice\[10\].u_fa/a_952_112# bitslice\[9\].u_fa/a_952_112# 0.03505f
C1569 bitslice\[20\].u_fa/CI s[20] 0.00205f
C1570 bitslice\[7\].u_fa/a_2012_472# bitslice\[7\].u_fa/a_1072_496# 0.00406f
C1571 bitslice\[15\].u_fa/a_512_496# bitslice\[15\].u_fa/a_124_46# 0.00639f
C1572 bitslice\[4\].u_fa/CI bitslice\[3\].u_fa/a_3048_156# 0.00141f
C1573 VPWR bitslice\[13\].u_fa/a_3028_472# 0.00593f
C1574 VPWR bitslice\[16\].u_fa/CI 0.72367f
C1575 VPWR bitslice\[19\].u_fa/a_512_496# 0.00292f
C1576 bitslice\[5\].u_fa/a_1072_156# VPWR 0.01572f
C1577 VPWR s[1] 0.29039f
C1578 b[15] bitslice\[15\].u_fa/a_1072_156# 0.0302f
C1579 s[15] bitslice\[15\].u_fa/a_680_156# 0
C1580 bitslice\[14\].u_fa/CI bitslice\[13\].u_fa/a_952_112# 0.12032f
C1581 bitslice\[0\].u_fa/a_952_112# bitslice\[0\].u_fa/a_1072_156# 0.00934f
C1582 VPWR bitslice\[5\].u_fa/a_952_112# 0.59588f
C1583 bitslice\[14\].u_fa/a_124_46# s[14] 0.26234f
C1584 a[12] a[13] 0.04751f
C1585 a[1] bitslice\[1\].u_fa/a_512_496# 0.002f
C1586 s[1] bitslice\[1\].u_fa/a_1072_496# 0
C1587 bitslice\[5\].u_fa/a_2012_472# bitslice\[5\].u_fa/a_1072_496# 0.00406f
C1588 a[16] bitslice\[16\].u_fa/a_124_46# 0.60698f
C1589 s[16] bitslice\[16\].u_fa/a_512_496# 0.00137f
C1590 bitslice\[13\].u_fa/CI s[13] 0.00239f
C1591 bitslice\[10\].u_fa/a_1992_156# bitslice\[10\].u_fa/a_1072_156# 0.00753f
C1592 a[12] b[12] 0.46601f
C1593 bitslice\[20\].u_fa/CI VPWR 0.72974f
C1594 a[0] s[0] 0.17692f
C1595 b[19] bitslice\[20\].u_fa/CI 0.08552f
C1596 bitslice\[20\].u_fa/a_952_112# bitslice\[20\].u_fa/a_124_46# 0.01486f
C1597 b[2] bitslice\[1\].u_fa/a_952_112# 0.00242f
C1598 s[3] b[3] 0.00392f
C1599 bitslice\[2\].u_fa/CI bitslice\[3\].u_fa/a_3028_472# 0
C1600 s[19] bitslice\[19\].u_fa/a_1072_496# 0
C1601 bitslice\[7\].u_fa/CI bitslice\[7\].u_fa/a_3028_472# 0.00336f
C1602 bitslice\[16\].u_fa/a_3048_156# bitslice\[16\].u_fa/CI 0.00123f
C1603 b[16] b[15] 0.1159f
C1604 a[19] bitslice\[19\].u_fa/CI 0.22669f
C1605 b[20] u_msb_x3/a_1336_472# 0.03208f
C1606 bitslice\[1\].u_fa/CI s[1] 0.00239f
C1607 bitslice\[15\].u_fa/CI b[14] 0.09066f
C1608 b[14] b[13] 0.1159f
C1609 s[9] bitslice\[9\].u_fa/a_1072_496# 0
C1610 bitslice\[9\].u_fa/a_2012_472# b[9] 0.02435f
C1611 bitslice\[8\].u_fa/a_2012_472# b[8] 0.02435f
C1612 bitslice\[12\].u_fa/a_512_156# bitslice\[12\].u_fa/a_124_46# 0.00257f
C1613 bitslice\[12\].u_fa/a_2012_472# bitslice\[12\].u_fa/a_1072_496# 0.00406f
C1614 bitslice\[11\].u_fa/a_124_46# bitslice\[11\].u_fa/a_1072_156# 0.0288f
C1615 bitslice\[15\].u_fa/a_124_46# bitslice\[15\].u_fa/a_680_496# 0.00655f
C1616 a[14] bitslice\[14\].u_fa/a_1992_156# 0.03766f
C1617 bitslice\[14\].u_fa/a_1072_496# bitslice\[14\].u_fa/a_512_496# 0
C1618 bitslice\[2\].u_fa/a_512_156# bitslice\[2\].u_fa/a_124_46# 0.00257f
C1619 bitslice\[19\].u_fa/a_1072_156# VPWR 0.01572f
C1620 bitslice\[13\].u_fa/a_512_496# bitslice\[13\].u_fa/a_124_46# 0.00639f
C1621 bitslice\[5\].u_fa/a_512_156# VPWR 0
C1622 bitslice\[5\].u_fa/a_512_496# a[5] 0.002f
C1623 FILLER_21_2/a_124_375# FILLER_21_2/a_484_472# 0.08674f
C1624 b[19] bitslice\[19\].u_fa/a_1072_156# 0.0302f
C1625 a[21] FILLER_21_2/a_572_375# 0.01514f
C1626 bitslice\[5\].u_fa/a_124_46# bitslice\[5\].u_fa/a_680_496# 0.00655f
C1627 a[4] bitslice\[4\].u_fa/a_512_496# 0
C1628 bitslice\[20\].u_fa/a_124_46# bitslice\[20\].u_fa/a_512_496# 0.00639f
C1629 bitslice\[13\].u_fa/a_1072_496# b[13] 0.02505f
C1630 a[10] bitslice\[8\].u_fa/CI 0
C1631 b[5] bitslice\[4\].u_fa/a_952_112# 0.002f
C1632 a[11] a[12] 0.86295f
C1633 u_msb_x3/A3 bitslice\[19\].u_fa/a_952_112# 0.00332f
C1634 bitslice\[2\].u_fa/a_3048_156# bitslice\[2\].u_fa/CI 0.00123f
C1635 b[18] bitslice\[18\].u_fa/a_1072_156# 0.0302f
C1636 s[18] bitslice\[18\].u_fa/a_680_156# 0
C1637 bitslice\[17\].u_fa/CI b[16] 0.09026f
C1638 bitslice\[16\].u_fa/CI bitslice\[16\].u_fa/a_1072_496# 0.00434f
C1639 bitslice\[20\].u_fa/a_952_112# b[20] 0.77863f
C1640 a[0] b[1] 0
C1641 s[5] s[4] 0.00769f
C1642 bitslice\[7\].u_fa/a_952_112# b[8] 0.00242f
C1643 bitslice\[8\].u_fa/a_3028_472# bitslice\[8\].u_fa/a_2012_472# 0
C1644 bitslice\[19\].u_fa/a_2012_472# bitslice\[19\].u_fa/CI 0.00772f
C1645 bitslice\[12\].u_fa/CI b[13] 0.00269f
C1646 bitslice\[13\].u_fa/a_512_156# s[13] 0.00108f
C1647 bitslice\[3\].u_fa/CI b[1] 0.00218f
C1648 a[21] b[21] 0.36965f
C1649 bitslice\[13\].u_fa/a_3028_472# bitslice\[13\].u_fa/CI 0.00336f
C1650 bitslice\[18\].u_fa/CI VPWR 0.73782f
C1651 bitslice\[11\].u_fa/a_1992_156# a[11] 0.03757f
C1652 VPWR bitslice\[8\].u_fa/a_512_156# 0
C1653 b[19] bitslice\[18\].u_fa/CI 0.00461f
C1654 a[10] bitslice\[10\].u_fa/a_680_496# 0
C1655 bitslice\[20\].u_fa/a_1072_496# bitslice\[20\].u_fa/a_2012_472# 0.00406f
C1656 s[21] u_msb_x3/a_728_93# 0.41912f
C1657 bitslice\[10\].u_fa/a_952_112# bitslice\[9\].u_fa/CI 0.00178f
C1658 bitslice\[9\].u_fa/a_124_46# bitslice\[9\].u_fa/a_512_496# 0.00639f
C1659 bitslice\[7\].u_fa/a_1992_156# a[7] 0.03757f
C1660 a[14] a[13] 0.86295f
C1661 bitslice\[0\].u_fa/a_952_112# bitslice\[0\].u_fa/a_3048_156# 0.00316f
C1662 u_msb_x3/a_56_524# b[21] 0.61737f
C1663 a[14] bitslice\[14\].u_fa/a_512_156# 0
C1664 bitslice\[14\].u_fa/a_1992_156# b[14] 0.03179f
C1665 bitslice\[2\].u_fa/a_1072_156# bitslice\[2\].u_fa/a_124_46# 0.0288f
C1666 a[21] bitslice\[19\].u_fa/a_124_46# 0.00206f
C1667 u_msb_x3/a_1936_472# u_msb_x3/a_728_93# 0.106f
C1668 bitslice\[13\].u_fa/a_1072_156# a[13] 0.03679f
C1669 b[9] bitslice\[8\].u_fa/a_124_46# 0
C1670 a[9] bitslice\[8\].u_fa/CI 0.00255f
C1671 a[18] bitslice\[19\].u_fa/a_124_46# 0
C1672 VPWR bitslice\[1\].u_fa/a_124_46# 0.46957f
C1673 bitslice\[7\].u_fa/CI bitslice\[7\].u_fa/a_1992_156# 0.69584f
C1674 bitslice\[1\].u_fa/a_1072_496# bitslice\[1\].u_fa/a_124_46# 0.0139f
C1675 bitslice\[18\].u_fa/CI bitslice\[16\].u_fa/a_3048_156# 0
C1676 bitslice\[9\].u_fa/CO b[10] 0.34555f
C1677 bitslice\[4\].u_fa/a_1072_496# bitslice\[4\].u_fa/a_124_46# 0.0139f
C1678 bitslice\[15\].u_fa/CI bitslice\[15\].u_fa/a_124_46# 0.27486f
C1679 s[20] bitslice\[20\].u_fa/a_1072_496# 0.00165f
C1680 b[5] bitslice\[7\].u_fa/CI 0.00218f
C1681 bitslice\[11\].u_fa/a_124_46# a[10] 0
C1682 bitslice\[17\].u_fa/a_124_46# a[18] 0.00806f
C1683 a[8] b[9] 0
C1684 s[12] bitslice\[12\].u_fa/a_952_112# 0.00117f
C1685 a[0] bitslice\[0\].u_fa/a_1992_156# 0.03766f
C1686 VPWR bitslice\[15\].u_fa/a_1072_496# 0.28074f
C1687 bitslice\[4\].u_fa/CI bitslice\[5\].u_fa/CI 0.06652f
C1688 bitslice\[9\].u_fa/a_124_46# bitslice\[10\].u_fa/a_124_46# 0.01624f
C1689 bitslice\[20\].u_fa/a_1992_156# a[21] 0
C1690 b[4] bitslice\[4\].u_fa/a_3028_472# 0.00428f
C1691 bitslice\[1\].u_fa/a_1992_156# bitslice\[2\].u_fa/CI 0.001f
C1692 b[1] bitslice\[1\].u_fa/a_1072_156# 0.0302f
C1693 bitslice\[18\].u_fa/a_1072_496# b[18] 0.02505f
C1694 a[4] bitslice\[4\].u_fa/a_1992_156# 0.03766f
C1695 a[0] bitslice\[0\].u_fa/a_680_156# 0
C1696 VPWR bitslice\[18\].u_fa/a_952_112# 0.59588f
C1697 bitslice\[11\].u_fa/a_680_156# s[11] 0
C1698 a[15] bitslice\[15\].u_fa/a_952_112# 0.17786f
C1699 VPWR bitslice\[20\].u_fa/a_1072_496# 0.28074f
C1700 bitslice\[8\].u_fa/a_1992_156# bitslice\[8\].u_fa/CI 0.70111f
C1701 s[2] bitslice\[2\].u_fa/a_124_46# 0.26234f
C1702 VPWR bitslice\[6\].u_fa/a_1072_156# 0.01572f
C1703 b[19] bitslice\[18\].u_fa/a_952_112# 0.00226f
C1704 bitslice\[19\].u_fa/CI bitslice\[18\].u_fa/a_3028_472# 0.00124f
C1705 bitslice\[2\].u_fa/a_952_112# VPWR 0.59588f
C1706 bitslice\[1\].u_fa/CI bitslice\[1\].u_fa/a_124_46# 0.27486f
C1707 u_msb_x3/a_56_524# a[21] 0.91739f
C1708 a[20] FILLER_21_2/a_484_472# 0
C1709 a[14] s[14] 0.17692f
C1710 VPWR bitslice\[0\].u_fa/a_1072_156# 0.01482f
C1711 b[10] bitslice\[9\].u_fa/a_952_112# 0.00242f
C1712 b[17] s[17] 0.00392f
C1713 bitslice\[3\].u_fa/a_512_496# a[3] 0.002f
C1714 VPWR bitslice\[8\].u_fa/a_1072_496# 0.28074f
C1715 bitslice\[17\].u_fa/a_124_46# a[17] 0.60604f
C1716 bitslice\[2\].u_fa/CI b[0] 0.00259f
C1717 VPWR b[3] 1.90176f
C1718 VPWR bitslice\[4\].u_fa/a_512_496# 0.00292f
C1719 VPWR u_msb_x3/a_728_93# 0.94629f
C1720 bitslice\[12\].u_fa/a_2012_472# bitslice\[12\].u_fa/a_3028_472# 0
C1721 VPWR bitslice\[16\].u_fa/a_124_46# 0.46952f
C1722 bitslice\[1\].u_fa/CI bitslice\[2\].u_fa/a_952_112# 0
C1723 b[4] bitslice\[4\].u_fa/a_1072_496# 0.02505f
C1724 bitslice\[8\].u_fa/CI a[7] 0.01364f
C1725 bitslice\[7\].u_fa/CI bitslice\[6\].u_fa/a_3028_472# 0.00124f
C1726 bitslice\[3\].u_fa/a_680_496# a[3] 0.00136f
C1727 a[20] bitslice\[20\].u_fa/CI 0.22372f
C1728 u_msb_x3/a_244_524# VPWR 0.00432f
C1729 bitslice\[13\].u_fa/a_1072_496# a[13] 0.02208f
C1730 bitslice\[6\].u_fa/a_952_112# a[7] 0
C1731 a[18] a[17] 0.86295f
C1732 bitslice\[0\].u_fa/a_124_46# s[0] 0.26234f
C1733 bitslice\[7\].u_fa/a_952_112# bitslice\[7\].u_fa/a_124_46# 0.01486f
C1734 u_msb_x3/a_1524_472# u_msb_x3/a_1336_472# 0.00134f
C1735 VPWR bitslice\[7\].u_fa/a_1072_496# 0.28074f
C1736 bitslice\[3\].u_fa/a_1072_496# bitslice\[3\].u_fa/CI 0.00463f
C1737 bitslice\[3\].u_fa/a_1992_156# b[3] 0.03179f
C1738 bitslice\[2\].u_fa/a_952_112# bitslice\[2\].u_fa/a_1072_496# 0.64312f
C1739 bitslice\[7\].u_fa/CI bitslice\[8\].u_fa/CI 0.0903f
C1740 s[17] a[16] 0
C1741 bitslice\[5\].u_fa/a_1072_496# VPWR 0.28074f
C1742 a[19] bitslice\[19\].u_fa/a_1072_496# 0.02208f
C1743 VPWR bitslice\[10\].u_fa/a_1072_156# 0.01572f
C1744 VPWR s[12] 0.34826f
C1745 bitslice\[19\].u_fa/CI bitslice\[19\].u_fa/a_124_46# 0.27486f
C1746 bitslice\[12\].u_fa/CI a[13] 0.00113f
C1747 bitslice\[18\].u_fa/CI s[18] 0.00205f
C1748 bitslice\[18\].u_fa/CI bitslice\[17\].u_fa/a_3048_156# 0.00121f
C1749 bitslice\[17\].u_fa/a_2012_472# bitslice\[17\].u_fa/CI 0.00772f
C1750 bitslice\[10\].u_fa/a_3028_472# bitslice\[10\].u_fa/a_2012_472# 0
C1751 bitslice\[3\].u_fa/a_1072_156# a[3] 0.03679f
C1752 u_msb_x3/a_2215_68# FILLER_21_2/a_572_375# 0
C1753 bitslice\[6\].u_fa/a_952_112# bitslice\[7\].u_fa/CI 0.11504f
C1754 bitslice\[20\].u_fa/a_124_46# bitslice\[20\].u_fa/a_680_496# 0.00655f
C1755 a[2] bitslice\[3\].u_fa/CI 0.01041f
C1756 a[12] bitslice\[12\].u_fa/a_680_156# 0
C1757 s[6] bitslice\[6\].u_fa/a_512_496# 0.00137f
C1758 b[11] bitslice\[11\].u_fa/a_1072_156# 0.0302f
C1759 b[13] bitslice\[13\].u_fa/a_1992_156# 0.03179f
C1760 bitslice\[12\].u_fa/CI b[12] 0.34555f
C1761 s[15] bitslice\[15\].u_fa/a_1072_496# 0
C1762 bitslice\[8\].u_fa/a_952_112# bitslice\[8\].u_fa/a_1072_496# 0.64312f
C1763 bitslice\[19\].u_fa/a_680_496# s[19] 0
C1764 u_msb_x3/a_1336_472# u_msb_x3/A3 0.50074f
C1765 a[21] bitslice\[19\].u_fa/CI 0.00479f
C1766 b[14] s[14] 0.00338f
C1767 a[6] bitslice\[7\].u_fa/a_124_46# 0
C1768 b[18] bitslice\[18\].u_fa/a_124_46# 0.05484f
C1769 bitslice\[3\].u_fa/CI bitslice\[3\].u_fa/a_2012_472# 0.00772f
C1770 a[8] bitslice\[8\].u_fa/a_2012_472# 0.01748f
C1771 bitslice\[2\].u_fa/a_680_496# s[2] 0
C1772 bitslice\[17\].u_fa/a_1072_156# bitslice\[17\].u_fa/a_1992_156# 0.00753f
C1773 bitslice\[1\].u_fa/a_952_112# b[0] 0.00248f
C1774 FILLER_21_2/a_124_375# u_msb_x3/a_728_93# 0
C1775 bitslice\[19\].u_fa/CI a[18] 0.01153f
C1776 cin a[0] 0.21845f
C1777 VPWR bitslice\[11\].u_fa/a_3028_472# 0.00593f
C1778 bitslice\[9\].u_fa/CO bitslice\[10\].u_fa/a_1072_496# 0.00434f
C1779 bitslice\[16\].u_fa/a_1072_496# bitslice\[16\].u_fa/a_124_46# 0.0139f
C1780 bitslice\[8\].u_fa/CI bitslice\[9\].u_fa/a_3048_156# 0
C1781 bitslice\[14\].u_fa/CI a[15] 0
C1782 bitslice\[12\].u_fa/a_952_112# bitslice\[12\].u_fa/a_124_46# 0.01486f
C1783 b[3] bitslice\[3\].u_fa/a_124_46# 0.05484f
C1784 bitslice\[0\].u_fa/a_124_46# b[1] 0
C1785 bitslice\[14\].u_fa/a_952_112# VPWR 0.59588f
C1786 bitslice\[19\].u_fa/a_2012_472# bitslice\[19\].u_fa/a_1072_496# 0.00406f
C1787 b[6] a[7] 0
C1788 a[8] s[9] 0
C1789 s[5] bitslice\[5\].u_fa/CI 0.00239f
C1790 bitslice\[3\].u_fa/a_952_112# bitslice\[3\].u_fa/CI 2.44171f
C1791 bitslice\[3\].u_fa/CI bitslice\[4\].u_fa/a_952_112# 0
C1792 bitslice\[1\].u_fa/a_952_112# bitslice\[1\].u_fa/a_2012_472# 0.7796f
C1793 bitslice\[20\].u_fa/a_952_112# u_msb_x3/A3 0.13084f
C1794 bitslice\[13\].u_fa/a_124_46# s[13] 0.26222f
C1795 bitslice\[6\].u_fa/a_124_46# bitslice\[7\].u_fa/a_124_46# 0.02943f
C1796 bitslice\[9\].u_fa/CI bitslice\[7\].u_fa/a_3048_156# 0
C1797 a[20] bitslice\[18\].u_fa/CI 0
C1798 bitslice\[12\].u_fa/CI a[11] 0.01364f
C1799 b[15] bitslice\[16\].u_fa/a_952_112# 0.0025f
C1800 s[18] bitslice\[18\].u_fa/a_952_112# 0.00117f
C1801 a[16] bitslice\[16\].u_fa/a_1992_156# 0.03766f
C1802 bitslice\[11\].u_fa/a_952_112# bitslice\[9\].u_fa/CO 0.00139f
C1803 b[10] bitslice\[9\].u_fa/CI 0.00212f
C1804 bitslice\[7\].u_fa/CI b[6] 0.09026f
C1805 bitslice\[11\].u_fa/a_1072_496# bitslice\[11\].u_fa/a_952_112# 0.64312f
C1806 bitslice\[19\].u_fa/CI a[17] 0
C1807 a[16] bitslice\[16\].u_fa/a_680_156# 0
C1808 VPWR bitslice\[18\].u_fa/a_2012_472# 0.29058f
C1809 bitslice\[4\].u_fa/a_952_112# bitslice\[4\].u_fa/a_124_46# 0.01486f
C1810 bitslice\[8\].u_fa/a_680_496# bitslice\[8\].u_fa/a_1072_496# 0
C1811 bitslice\[2\].u_fa/a_3028_472# VPWR 0.00593f
C1812 bitslice\[13\].u_fa/a_512_496# a[13] 0.002f
C1813 VPWR bitslice\[19\].u_fa/a_512_156# 0
C1814 u_msb_x3/A3 bitslice\[20\].u_fa/a_512_496# 0
C1815 a[15] bitslice\[15\].u_fa/a_1072_156# 0.03679f
C1816 bitslice\[14\].u_fa/a_1072_156# bitslice\[14\].u_fa/a_952_112# 0.00934f
C1817 u_msb_x3/a_2215_68# a[21] 0
C1818 bitslice\[11\].u_fa/a_124_46# a[11] 0.60604f
C1819 b[1] bitslice\[1\].u_fa/a_3028_472# 0.00428f
C1820 bitslice\[14\].u_fa/a_1072_496# VPWR 0.28074f
C1821 bitslice\[1\].u_fa/CI bitslice\[0\].u_fa/a_3048_156# 0
C1822 a[16] bitslice\[16\].u_fa/a_680_496# 0
C1823 b[16] bitslice\[16\].u_fa/a_3028_472# 0.00428f
C1824 bitslice\[17\].u_fa/CI bitslice\[16\].u_fa/a_952_112# 0.11504f
C1825 a[9] b[9] 0.46488f
C1826 bitslice\[12\].u_fa/a_952_112# bitslice\[11\].u_fa/CI 0
C1827 b[11] a[10] 0
C1828 bitslice\[14\].u_fa/CI bitslice\[15\].u_fa/a_952_112# 0.00106f
C1829 bitslice\[17\].u_fa/a_680_156# VPWR 0
C1830 bitslice\[4\].u_fa/a_952_112# a[5] 0
C1831 b[17] b[18] 0.1032f
C1832 VPWR s[11] 0.29039f
C1833 b[2] VPWR 1.90361f
C1834 bitslice\[2\].u_fa/CI bitslice\[2\].u_fa/a_124_46# 0.27486f
C1835 a[19] bitslice\[18\].u_fa/a_124_46# 0.00783f
C1836 bitslice\[6\].u_fa/a_680_496# bitslice\[6\].u_fa/a_1072_496# 0
C1837 bitslice\[0\].u_fa/a_512_496# VPWR 0.00292f
C1838 b[17] bitslice\[17\].u_fa/CI 0.41328f
C1839 bitslice\[0\].u_fa/a_124_46# bitslice\[0\].u_fa/a_680_156# 0.00316f
C1840 s[19] bitslice\[19\].u_fa/a_680_156# 0
C1841 a[20] bitslice\[20\].u_fa/a_1072_496# 0.01952f
C1842 bitslice\[8\].u_fa/a_1072_156# bitslice\[8\].u_fa/CI 0.61603f
C1843 bitslice\[4\].u_fa/CI bitslice\[4\].u_fa/a_3048_156# 0.00123f
C1844 VPWR bitslice\[12\].u_fa/a_124_46# 0.46952f
C1845 bitslice\[14\].u_fa/a_952_112# bitslice\[14\].u_fa/a_2012_472# 0.7796f
C1846 s[1] s[0] 0.00769f
C1847 a[10] s[10] 0.17692f
C1848 b[16] bitslice\[17\].u_fa/a_124_46# 0
C1849 b[8] bitslice\[8\].u_fa/a_1072_496# 0.02505f
C1850 bitslice\[12\].u_fa/a_1072_156# bitslice\[12\].u_fa/a_952_112# 0.00934f
C1851 bitslice\[2\].u_fa/a_512_156# s[2] 0
C1852 bitslice\[3\].u_fa/a_952_112# b[4] 0.00242f
C1853 a[14] bitslice\[14\].u_fa/a_124_46# 0.60698f
C1854 b[4] bitslice\[4\].u_fa/a_952_112# 0.7795f
C1855 bitslice\[14\].u_fa/a_3028_472# bitslice\[14\].u_fa/CI 0.00103f
C1856 bitslice\[1\].u_fa/CI b[2] 0
C1857 a[13] bitslice\[13\].u_fa/a_1992_156# 0.03757f
C1858 u_msb_x3/A3 bitslice\[19\].u_fa/a_3028_472# 0
C1859 a[4] bitslice\[4\].u_fa/CI 0.22343f
C1860 bitslice\[15\].u_fa/a_1072_156# bitslice\[15\].u_fa/a_952_112# 0.00934f
C1861 bitslice\[17\].u_fa/CI bitslice\[17\].u_fa/a_3028_472# 0.00336f
C1862 a[18] bitslice\[18\].u_fa/a_1072_156# 0.03894f
C1863 bitslice\[17\].u_fa/CI a[16] 0.01041f
C1864 a[10] s[9] 0.19959f
C1865 a[0] a[1] 0.04751f
C1866 bitslice\[0\].u_fa/a_952_112# b[0] 0.78089f
C1867 b[2] bitslice\[2\].u_fa/a_1072_496# 0.02505f
C1868 b[13] s[13] 0.00392f
C1869 bitslice\[5\].u_fa/a_124_46# bitslice\[5\].u_fa/CI 0.27486f
C1870 bitslice\[4\].u_fa/a_1072_156# bitslice\[4\].u_fa/a_124_46# 0.0288f
C1871 bitslice\[14\].u_fa/a_1072_496# bitslice\[14\].u_fa/a_2012_472# 0.00406f
C1872 s[7] bitslice\[7\].u_fa/a_952_112# 0.00192f
C1873 s[17] VPWR 0.29039f
C1874 bitslice\[19\].u_fa/a_1072_496# bitslice\[19\].u_fa/a_124_46# 0.0139f
C1875 b[16] bitslice\[15\].u_fa/a_952_112# 0.00242f
C1876 s[1] b[1] 0.00392f
C1877 VPWR bitslice\[11\].u_fa/CI 0.93267f
C1878 bitslice\[17\].u_fa/a_952_112# bitslice\[16\].u_fa/CI 0.00139f
C1879 b[5] bitslice\[5\].u_fa/a_3028_472# 0.00428f
C1880 b[10] bitslice\[10\].u_fa/a_1992_156# 0.03179f
C1881 VPWR bitslice\[3\].u_fa/a_3028_472# 0.00593f
C1882 b[2] bitslice\[3\].u_fa/a_124_46# 0
C1883 a[9] s[10] 0
C1884 bitslice\[20\].u_fa/a_124_46# b[20] 0.05484f
C1885 a[2] bitslice\[2\].u_fa/a_1992_156# 0.03766f
C1886 bitslice\[20\].u_fa/CI bitslice\[19\].u_fa/a_952_112# 0.1229f
C1887 b[16] a[17] 0
C1888 bitslice\[0\].u_fa/a_952_112# bitslice\[0\].u_fa/a_2012_472# 0.7796f
C1889 a[19] bitslice\[19\].u_fa/a_680_496# 0.00136f
C1890 a[21] bitslice\[19\].u_fa/a_1072_496# 0
C1891 VPWR bitslice\[15\].u_fa/a_3028_472# 0.00593f
C1892 b[14] bitslice\[14\].u_fa/a_124_46# 0.05484f
C1893 a[6] s[7] 0
C1894 VPWR bitslice\[1\].u_fa/a_680_496# 0.00283f
C1895 VPWR bitslice\[12\].u_fa/a_1072_156# 0.01572f
C1896 s[20] s[19] 0.00743f
C1897 bitslice\[1\].u_fa/a_1072_496# bitslice\[1\].u_fa/a_680_496# 0
C1898 VPWR bitslice\[10\].u_fa/a_952_112# 0.59588f
C1899 bitslice\[6\].u_fa/CI bitslice\[4\].u_fa/a_952_112# 0
C1900 cin bitslice\[0\].u_fa/a_124_46# 0.27486f
C1901 bitslice\[10\].u_fa/a_680_496# bitslice\[10\].u_fa/a_124_46# 0.00655f
C1902 bitslice\[2\].u_fa/a_952_112# bitslice\[2\].u_fa/a_2012_472# 0.7796f
C1903 bitslice\[6\].u_fa/a_952_112# bitslice\[6\].u_fa/a_3048_156# 0.00316f
C1904 s[20] bitslice\[20\].u_fa/a_512_156# 0
C1905 b[11] b[12] 0.1159f
C1906 a[12] bitslice\[12\].u_fa/a_512_496# 0
C1907 s[12] bitslice\[12\].u_fa/a_1072_496# 0.00165f
C1908 b[12] bitslice\[12\].u_fa/a_2012_472# 0.02435f
C1909 VPWR bitslice\[13\].u_fa/a_2012_472# 0.29058f
C1910 bitslice\[17\].u_fa/a_1072_496# bitslice\[17\].u_fa/a_512_496# 0
C1911 s[9] a[9] 0.17996f
C1912 bitslice\[8\].u_fa/a_512_496# VPWR 0.00292f
C1913 bitslice\[4\].u_fa/a_2012_472# bitslice\[5\].u_fa/CI 0
C1914 bitslice\[19\].u_fa/a_1072_156# bitslice\[19\].u_fa/a_952_112# 0.00934f
C1915 b[4] bitslice\[4\].u_fa/a_1072_156# 0.0302f
C1916 s[14] bitslice\[14\].u_fa/a_680_156# 0
C1917 cin bitslice\[2\].u_fa/a_1992_156# 0
C1918 a[1] bitslice\[1\].u_fa/a_1072_156# 0.03679f
C1919 bitslice\[18\].u_fa/a_1072_496# a[18] 0.01952f
C1920 VPWR s[19] 0.29039f
C1921 VPWR bitslice\[20\].u_fa/a_512_156# 0
C1922 b[19] s[19] 0.00392f
C1923 bitslice\[10\].u_fa/a_680_156# s[10] 0
C1924 bitslice\[15\].u_fa/CI bitslice\[16\].u_fa/CI 0.0903f
C1925 bitslice\[20\].u_fa/a_680_496# u_msb_x3/A3 0
C1926 bitslice\[8\].u_fa/a_512_156# bitslice\[8\].u_fa/a_124_46# 0.00257f
C1927 bitslice\[11\].u_fa/a_124_46# bitslice\[10\].u_fa/a_124_46# 0.02943f
C1928 bitslice\[13\].u_fa/a_3028_472# b[13] 0.00428f
C1929 VPWR bitslice\[16\].u_fa/a_680_156# 0
C1930 b[11] bitslice\[11\].u_fa/a_2012_472# 0.02435f
C1931 bitslice\[15\].u_fa/a_512_496# bitslice\[15\].u_fa/a_1072_496# 0
C1932 bitslice\[6\].u_fa/CI a[7] 0.00113f
C1933 a[8] bitslice\[8\].u_fa/a_512_156# 0
C1934 bitslice\[8\].u_fa/CI bitslice\[7\].u_fa/a_3028_472# 0
C1935 bitslice\[13\].u_fa/a_952_112# bitslice\[12\].u_fa/a_952_112# 0.02943f
C1936 a[6] bitslice\[6\].u_fa/a_680_496# 0
C1937 VPWR bitslice\[9\].u_fa/a_680_496# 0.00283f
C1938 s[5] a[4] 0
C1939 bitslice\[18\].u_fa/CI bitslice\[19\].u_fa/a_952_112# 0.0027f
C1940 b[11] a[11] 0.46296f
C1941 VPWR bitslice\[16\].u_fa/a_680_496# 0.00283f
C1942 VPWR bitslice\[4\].u_fa/CI 0.72208f
C1943 bitslice\[9\].u_fa/a_1072_156# a[9] 0.03679f
C1944 a[6] bitslice\[6\].u_fa/a_680_156# 0
C1945 bitslice\[6\].u_fa/CI bitslice\[7\].u_fa/CI 0.06088f
C1946 bitslice\[18\].u_fa/CI bitslice\[17\].u_fa/a_952_112# 0.12603f
C1947 bitslice\[7\].u_fa/a_1072_496# bitslice\[7\].u_fa/a_124_46# 0.0139f
C1948 bitslice\[6\].u_fa/a_124_46# bitslice\[6\].u_fa/a_680_496# 0.00655f
C1949 a[11] s[10] 0.20011f
C1950 bitslice\[14\].u_fa/a_124_46# bitslice\[15\].u_fa/a_124_46# 0.02943f
C1951 s[17] s[18] 0.00743f
C1952 bitslice\[19\].u_fa/a_124_46# bitslice\[18\].u_fa/a_124_46# 0.02943f
C1953 VPWR b[15] 1.90176f
C1954 a[13] s[13] 0.1788f
C1955 s[8] VPWR 0.34826f
C1956 bitslice\[19\].u_fa/CI bitslice\[19\].u_fa/a_1072_496# 0.00463f
C1957 bitslice\[17\].u_fa/a_124_46# bitslice\[18\].u_fa/a_124_46# 0.01624f
C1958 b[1] bitslice\[1\].u_fa/a_124_46# 0.05484f
C1959 bitslice\[5\].u_fa/a_1072_496# bitslice\[5\].u_fa/a_512_496# 0
C1960 bitslice\[15\].u_fa/a_680_496# bitslice\[15\].u_fa/a_1072_496# 0
C1961 bitslice\[4\].u_fa/CI bitslice\[3\].u_fa/a_1992_156# 0.001f
C1962 bitslice\[6\].u_fa/a_124_46# bitslice\[6\].u_fa/a_680_156# 0.00316f
C1963 bitslice\[7\].u_fa/a_952_112# a[7] 0.17786f
C1964 bitslice\[12\].u_fa/CI a[12] 0.22372f
C1965 a[2] s[1] 0.19959f
C1966 bitslice\[8\].u_fa/a_124_46# bitslice\[8\].u_fa/a_1072_496# 0.0139f
C1967 bitslice\[13\].u_fa/a_2012_472# bitslice\[13\].u_fa/CI 0.00772f
C1968 bitslice\[3\].u_fa/CI a[3] 0.22669f
C1969 a[18] bitslice\[18\].u_fa/a_124_46# 0.60698f
C1970 bitslice\[18\].u_fa/a_952_112# bitslice\[19\].u_fa/a_952_112# 0.02943f
C1971 VPWR b[18] 1.90356f
C1972 VPWR b[0] 1.90263f
C1973 bitslice\[17\].u_fa/CI VPWR 0.93884f
C1974 a[8] bitslice\[8\].u_fa/a_1072_496# 0.01952f
C1975 bitslice\[7\].u_fa/CI bitslice\[7\].u_fa/a_952_112# 2.44171f
C1976 b[19] bitslice\[17\].u_fa/CI 0.00132f
C1977 b[19] b[18] 0.83145f
C1978 bitslice\[14\].u_fa/a_1072_496# bitslice\[14\].u_fa/a_680_496# 0
C1979 bitslice\[2\].u_fa/a_952_112# b[1] 0.0025f
C1980 bitslice\[1\].u_fa/CI bitslice\[1\].u_fa/a_1992_156# 0.69584f
C1981 bitslice\[16\].u_fa/a_3028_472# bitslice\[16\].u_fa/a_952_112# 0.00197f
C1982 bitslice\[16\].u_fa/a_1072_496# bitslice\[16\].u_fa/a_680_496# 0
C1983 bitslice\[17\].u_fa/a_952_112# bitslice\[18\].u_fa/a_952_112# 0.03505f
C1984 bitslice\[5\].u_fa/a_3048_156# bitslice\[6\].u_fa/CI 0.00141f
C1985 s[4] bitslice\[4\].u_fa/a_680_156# 0
C1986 bitslice\[11\].u_fa/a_124_46# a[12] 0.00806f
C1987 bitslice\[12\].u_fa/CI bitslice\[11\].u_fa/a_1992_156# 0.001f
C1988 bitslice\[12\].u_fa/a_1072_496# bitslice\[12\].u_fa/a_124_46# 0.0139f
C1989 bitslice\[0\].u_fa/a_124_46# a[1] 0.00783f
C1990 VPWR bitslice\[13\].u_fa/a_952_112# 0.59588f
C1991 a[6] a[7] 0.04751f
C1992 bitslice\[8\].u_fa/CI bitslice\[7\].u_fa/a_1992_156# 0.001f
C1993 VPWR bitslice\[1\].u_fa/a_2012_472# 0.29058f
C1994 bitslice\[17\].u_fa/a_2012_472# a[17] 0.01751f
C1995 bitslice\[4\].u_fa/a_124_46# a[3] 0
C1996 bitslice\[9\].u_fa/a_1992_156# bitslice\[9\].u_fa/CO 0.001f
C1997 bitslice\[1\].u_fa/a_1072_496# bitslice\[1\].u_fa/a_2012_472# 0.00406f
C1998 bitslice\[2\].u_fa/a_3028_472# bitslice\[2\].u_fa/a_2012_472# 0
C1999 s[21] FILLER_21_2/a_36_472# 0.01571f
C2000 bitslice\[3\].u_fa/CI bitslice\[3\].u_fa/a_1072_156# 0.61608f
C2001 s[14] s[13] 0.00743f
C2002 s[19] s[18] 0.00769f
C2003 bitslice\[4\].u_fa/a_952_112# bitslice\[5\].u_fa/a_952_112# 0.02943f
C2004 bitslice\[9\].u_fa/CI b[7] 0.00582f
C2005 a[18] bitslice\[18\].u_fa/a_512_496# 0
C2006 VPWR bitslice\[0\].u_fa/a_2012_472# 0.29058f
C2007 bitslice\[17\].u_fa/CI bitslice\[16\].u_fa/a_3048_156# 0
C2008 s[8] bitslice\[8\].u_fa/a_952_112# 0.00117f
C2009 bitslice\[6\].u_fa/a_952_112# b[5] 0.0025f
C2010 bitslice\[1\].u_fa/CI b[0] 0.09066f
C2011 a[14] b[14] 0.46601f
C2012 a[17] bitslice\[18\].u_fa/a_124_46# 0
C2013 bitslice\[7\].u_fa/CI a[6] 0.01041f
C2014 bitslice\[2\].u_fa/a_1072_156# bitslice\[2\].u_fa/CI 0.61603f
C2015 bitslice\[6\].u_fa/a_124_46# a[7] 0.00783f
C2016 bitslice\[19\].u_fa/a_3048_156# u_msb_x3/A3 0
C2017 bitslice\[0\].u_fa/a_952_112# bitslice\[0\].u_fa/a_1072_496# 0.64312f
C2018 bitslice\[4\].u_fa/a_512_496# bitslice\[4\].u_fa/a_1072_496# 0
C2019 bitslice\[9\].u_fa/a_124_46# b[9] 0.05484f
C2020 bitslice\[19\].u_fa/a_680_496# bitslice\[19\].u_fa/a_124_46# 0.00655f
C2021 bitslice\[1\].u_fa/CI bitslice\[1\].u_fa/a_2012_472# 0.00772f
C2022 a[21] u_msb_x3/a_952_93# 0
C2023 b[2] bitslice\[2\].u_fa/a_2012_472# 0.02435f
C2024 bitslice\[5\].u_fa/a_124_46# a[4] 0
C2025 b[17] bitslice\[17\].u_fa/a_124_46# 0.05484f
C2026 bitslice\[15\].u_fa/CI bitslice\[15\].u_fa/a_1072_496# 0.00463f
C2027 bitslice\[16\].u_fa/CI bitslice\[15\].u_fa/a_1992_156# 0.001f
C2028 bitslice\[20\].u_fa/a_124_46# u_msb_x3/A3 0
C2029 s[5] VPWR 0.29039f
C2030 VPWR b[10] 1.90361f
C2031 s[15] b[15] 0.00392f
C2032 a[19] s[20] 0
C2033 s[1] bitslice\[1\].u_fa/a_680_156# 0
C2034 bitslice\[11\].u_fa/a_680_496# a[11] 0.00136f
C2035 s[16] bitslice\[16\].u_fa/a_512_156# 0
C2036 bitslice\[20\].u_fa/a_952_112# bitslice\[20\].u_fa/CI 2.43003f
C2037 bitslice\[1\].u_fa/CI bitslice\[0\].u_fa/a_2012_472# 0
C2038 a[21] bitslice\[19\].u_fa/a_680_496# 0
C2039 a[0] bitslice\[0\].u_fa/a_680_496# 0
C2040 u_msb_x3/a_56_524# u_msb_x3/a_952_93# 0
C2041 bitslice\[9\].u_fa/CO bitslice\[9\].u_fa/a_952_112# 0.12729f
C2042 bitslice\[0\].u_fa/a_1992_156# bitslice\[0\].u_fa/a_1072_156# 0.00753f
C2043 bitslice\[14\].u_fa/a_124_46# bitslice\[14\].u_fa/a_680_156# 0.00316f
C2044 bitslice\[2\].u_fa/CI s[2] 0.00205f
C2045 FILLER_21_2/a_36_472# s[20] 0.00332f
C2046 a[20] s[19] 0.19959f
C2047 bitslice\[9\].u_fa/a_1072_496# bitslice\[9\].u_fa/a_680_496# 0
C2048 a[19] VPWR 0.76087f
C2049 a[20] bitslice\[20\].u_fa/a_512_156# 0
C2050 b[19] a[19] 0.46296f
C2051 a[16] a[15] 0.86295f
C2052 VPWR bitslice\[12\].u_fa/a_680_496# 0.00283f
C2053 s[16] bitslice\[16\].u_fa/CI 0.00205f
C2054 bitslice\[16\].u_fa/a_952_112# bitslice\[15\].u_fa/a_952_112# 0.03505f
C2055 s[8] bitslice\[8\].u_fa/a_680_496# 0
C2056 VPWR u_msb_x3/a_718_524# 0.57977f
C2057 b[5] b[6] 0.1159f
C2058 b[11] bitslice\[10\].u_fa/a_124_46# 0
C2059 a[16] bitslice\[17\].u_fa/a_124_46# 0
C2060 bitslice\[6\].u_fa/a_952_112# bitslice\[6\].u_fa/a_3028_472# 0.00197f
C2061 bitslice\[7\].u_fa/CI bitslice\[5\].u_fa/a_952_112# 0
C2062 b[20] u_msb_x3/A3 0.2171f
C2063 bitslice\[12\].u_fa/CI bitslice\[11\].u_fa/a_3048_156# 0.00141f
C2064 a[2] bitslice\[1\].u_fa/a_124_46# 0.00806f
C2065 bitslice\[16\].u_fa/a_952_112# a[17] 0
C2066 FILLER_21_2/a_36_472# VPWR 0.24716f
C2067 bitslice\[13\].u_fa/a_952_112# bitslice\[13\].u_fa/CI 2.44277f
C2068 a[4] bitslice\[4\].u_fa/a_2012_472# 0.01748f
C2069 u_msb_x3/A3 bitslice\[19\].u_fa/a_1992_156# 0.00252f
C2070 bitslice\[11\].u_fa/a_512_496# s[11] 0
C2071 s[9] bitslice\[9\].u_fa/a_512_496# 0
C2072 VPWR bitslice\[6\].u_fa/a_512_156# 0
C2073 s[18] b[18] 0.00338f
C2074 bitslice\[0\].u_fa/a_512_496# s[0] 0.00137f
C2075 bitslice\[17\].u_fa/CI bitslice\[17\].u_fa/a_3048_156# 0
C2076 b[17] a[17] 0.46296f
C2077 bitslice\[10\].u_fa/a_124_46# s[10] 0.26234f
C2078 bitslice\[15\].u_fa/CI bitslice\[15\].u_fa/a_3048_156# 0
C2079 s[21] FILLER_21_2/a_572_375# 0.04769f
C2080 bitslice\[11\].u_fa/a_952_112# bitslice\[12\].u_fa/a_952_112# 0.03505f
C2081 a[14] bitslice\[15\].u_fa/a_124_46# 0
C2082 bitslice\[2\].u_fa/a_952_112# a[2] 0.17729f
C2083 bitslice\[19\].u_fa/a_2012_472# VPWR 0.29058f
C2084 b[19] bitslice\[19\].u_fa/a_2012_472# 0.02435f
C2085 s[7] bitslice\[7\].u_fa/a_1072_496# 0
C2086 b[7] bitslice\[7\].u_fa/a_2012_472# 0.02435f
C2087 bitslice\[20\].u_fa/a_952_112# bitslice\[18\].u_fa/CI 0
C2088 s[8] b[8] 0.00338f
C2089 bitslice\[12\].u_fa/a_124_46# bitslice\[13\].u_fa/a_124_46# 0.02943f
C2090 bitslice\[3\].u_fa/a_1072_496# b[3] 0.02505f
C2091 VPWR bitslice\[2\].u_fa/a_124_46# 0.46952f
C2092 bitslice\[19\].u_fa/a_680_156# bitslice\[19\].u_fa/a_124_46# 0.00316f
C2093 a[19] FILLER_21_2/a_124_375# 0
C2094 a[1] s[1] 0.1788f
C2095 bitslice\[11\].u_fa/CI bitslice\[10\].u_fa/a_2012_472# 0
C2096 s[21] b[21] 0
C2097 bitslice\[5\].u_fa/a_3048_156# bitslice\[5\].u_fa/a_952_112# 0.00316f
C2098 a[10] bitslice\[10\].u_fa/a_1072_156# 0.03894f
C2099 a[2] b[3] 0
C2100 bitslice\[6\].u_fa/CI bitslice\[6\].u_fa/a_3048_156# 0.00123f
C2101 b[6] bitslice\[6\].u_fa/a_3028_472# 0.00428f
C2102 bitslice\[20\].u_fa/CI bitslice\[19\].u_fa/a_3028_472# 0
C2103 a[16] a[17] 0.04492f
C2104 b[5] bitslice\[4\].u_fa/a_124_46# 0
C2105 b[17] bitslice\[19\].u_fa/CI 0.00283f
C2106 bitslice\[20\].u_fa/a_1072_156# a[21] 0.00221f
C2107 FILLER_21_2/a_36_472# FILLER_21_2/a_124_375# 0.30831f
C2108 b[2] b[1] 0.1159f
C2109 bitslice\[9\].u_fa/a_3028_472# bitslice\[8\].u_fa/CI 0
C2110 a[21] bitslice\[19\].u_fa/a_680_156# 0
C2111 bitslice\[20\].u_fa/a_1072_156# bitslice\[20\].u_fa/a_1992_156# 0.00753f
C2112 u_msb_x3/a_1936_472# b[21] 0
C2113 bitslice\[11\].u_fa/a_1072_156# s[11] 0
C2114 bitslice\[9\].u_fa/a_124_46# s[9] 0.26993f
C2115 bitslice\[9\].u_fa/a_1992_156# bitslice\[9\].u_fa/CI 0.69584f
C2116 bitslice\[15\].u_fa/CI bitslice\[14\].u_fa/a_952_112# 0.11627f
C2117 bitslice\[3\].u_fa/a_952_112# bitslice\[2\].u_fa/a_952_112# 0.02943f
C2118 b[6] bitslice\[8\].u_fa/CI 0.00259f
C2119 bitslice\[5\].u_fa/a_124_46# VPWR 0.46957f
C2120 bitslice\[10\].u_fa/a_3048_156# bitslice\[11\].u_fa/CI 0
C2121 VPWR bitslice\[10\].u_fa/a_1072_496# 0.28074f
C2122 b[3] bitslice\[3\].u_fa/a_2012_472# 0.02435f
C2123 bitslice\[14\].u_fa/a_952_112# b[13] 0.0033f
C2124 bitslice\[1\].u_fa/a_680_156# bitslice\[1\].u_fa/a_124_46# 0.00316f
C2125 bitslice\[18\].u_fa/CI bitslice\[18\].u_fa/a_1992_156# 0.6996f
C2126 bitslice\[10\].u_fa/a_2012_472# bitslice\[10\].u_fa/a_952_112# 0.7796f
C2127 bitslice\[10\].u_fa/a_1072_496# bitslice\[10\].u_fa/a_512_496# 0
C2128 bitslice\[9\].u_fa/CO bitslice\[9\].u_fa/CI 0.02956f
C2129 bitslice\[6\].u_fa/a_952_112# b[6] 0.77989f
C2130 a[12] bitslice\[12\].u_fa/a_2012_472# 0.01748f
C2131 cin bitslice\[0\].u_fa/a_1072_156# 0.61676f
C2132 b[14] bitslice\[15\].u_fa/a_124_46# 0
C2133 b[5] a[5] 0.46296f
C2134 bitslice\[3\].u_fa/a_952_112# b[3] 0.77779f
C2135 bitslice\[2\].u_fa/a_1072_496# bitslice\[2\].u_fa/a_124_46# 0.0139f
C2136 bitslice\[4\].u_fa/a_952_112# b[3] 0.0025f
C2137 bitslice\[20\].u_fa/a_952_112# bitslice\[20\].u_fa/a_1072_496# 0.64312f
C2138 u_msb_x3/a_1336_472# u_msb_x3/a_728_93# 0.63017f
C2139 VPWR bitslice\[18\].u_fa/a_3028_472# 0.00593f
C2140 bitslice\[18\].u_fa/a_1072_156# bitslice\[18\].u_fa/a_124_46# 0.0288f
C2141 a[0] bitslice\[0\].u_fa/a_512_156# 0
C2142 bitslice\[6\].u_fa/CI bitslice\[7\].u_fa/a_3028_472# 0
C2143 a[19] s[18] 0.20011f
C2144 bitslice\[10\].u_fa/a_3048_156# bitslice\[10\].u_fa/a_952_112# 0.00316f
C2145 VPWR FILLER_21_2/a_572_375# 0.34606f
C2146 s[21] a[21] 0.35874f
C2147 VPWR s[6] 0.34826f
C2148 VPWR bitslice\[0\].u_fa/a_1072_496# 0.28016f
C2149 VPWR bitslice\[11\].u_fa/a_952_112# 0.59588f
C2150 bitslice\[5\].u_fa/a_3028_472# bitslice\[6\].u_fa/CI 0
C2151 s[4] bitslice\[4\].u_fa/a_680_496# 0
C2152 b[11] bitslice\[11\].u_fa/a_1992_156# 0.03179f
C2153 bitslice\[2\].u_fa/a_124_46# bitslice\[3\].u_fa/a_124_46# 0.02943f
C2154 bitslice\[5\].u_fa/a_1992_156# bitslice\[5\].u_fa/CI 0.69584f
C2155 a[21] u_msb_x3/a_1936_472# 0.0148f
C2156 bitslice\[13\].u_fa/a_1072_156# bitslice\[13\].u_fa/a_1992_156# 0.00753f
C2157 b[7] bitslice\[7\].u_fa/a_1072_156# 0.0302f
C2158 s[21] u_msb_x3/a_56_524# 0
C2159 bitslice\[9\].u_fa/CI bitslice\[9\].u_fa/a_952_112# 2.41442f
C2160 bitslice\[9\].u_fa/a_124_46# bitslice\[9\].u_fa/a_1072_156# 0.0288f
C2161 b[5] b[4] 0.83145f
C2162 VPWR bitslice\[4\].u_fa/a_2012_472# 0.29058f
C2163 bitslice\[20\].u_fa/a_1072_496# bitslice\[20\].u_fa/a_512_496# 0
C2164 VPWR b[21] 0.39922f
C2165 bitslice\[2\].u_fa/a_680_496# VPWR 0.00283f
C2166 a[21] bitslice\[20\].u_fa/a_2012_472# 0.0011f
C2167 VPWR bitslice\[16\].u_fa/a_3028_472# 0.00593f
C2168 VPWR bitslice\[9\].u_fa/a_680_156# 0
C2169 bitslice\[9\].u_fa/CO bitslice\[8\].u_fa/a_3048_156# 0
C2170 bitslice\[18\].u_fa/CI bitslice\[19\].u_fa/a_3028_472# 0
C2171 b[19] b[21] 0
C2172 s[17] bitslice\[17\].u_fa/a_952_112# 0.00139f
C2173 VPWR VGND 0.12873p
C2174 bitslice\[2\].u_fa/CI VGND 1.079f
C2175 a[1] VGND 1.89078f
C2176 s[1] VGND 0.31753f
C2177 b[1] VGND 0.70474f
C2178 bitslice\[1\].u_fa/a_3048_156# VGND 0.00172f $ **FLOATING
C2179 bitslice\[1\].u_fa/a_1992_156# VGND 0.4914f $ **FLOATING
C2180 bitslice\[1\].u_fa/a_1072_156# VGND 0.29997f $ **FLOATING
C2181 bitslice\[1\].u_fa/a_680_156# VGND 0.00171f $ **FLOATING
C2182 bitslice\[1\].u_fa/a_512_156# VGND 0.00183f $ **FLOATING
C2183 bitslice\[1\].u_fa/a_3028_472# VGND 0 $ **FLOATING
C2184 bitslice\[1\].u_fa/a_2012_472# VGND 0.01495f $ **FLOATING
C2185 bitslice\[1\].u_fa/a_1072_496# VGND 0.0018f $ **FLOATING
C2186 bitslice\[1\].u_fa/a_952_112# VGND 0.56133f $ **FLOATING
C2187 bitslice\[1\].u_fa/a_124_46# VGND 0.48482f $ **FLOATING
C2188 bitslice\[19\].u_fa/CI VGND 0.93479f
C2189 a[18] VGND 1.96413f
C2190 s[18] VGND 0.26733f
C2191 b[18] VGND 0.70388f
C2192 bitslice\[18\].u_fa/a_3048_156# VGND 0.00173f $ **FLOATING
C2193 bitslice\[18\].u_fa/a_1992_156# VGND 0.4914f $ **FLOATING
C2194 bitslice\[18\].u_fa/a_1072_156# VGND 0.29997f $ **FLOATING
C2195 bitslice\[18\].u_fa/a_680_156# VGND 0.00171f $ **FLOATING
C2196 bitslice\[18\].u_fa/a_512_156# VGND 0.00183f $ **FLOATING
C2197 bitslice\[18\].u_fa/a_3028_472# VGND 0 $ **FLOATING
C2198 bitslice\[18\].u_fa/a_2012_472# VGND 0.01495f $ **FLOATING
C2199 bitslice\[18\].u_fa/a_1072_496# VGND 0.0018f $ **FLOATING
C2200 bitslice\[18\].u_fa/a_952_112# VGND 0.56133f $ **FLOATING
C2201 bitslice\[18\].u_fa/a_124_46# VGND 0.48482f $ **FLOATING
C2202 bitslice\[13\].u_fa/CI VGND 0.91404f
C2203 a[12] VGND 1.96389f
C2204 s[12] VGND 0.26733f
C2205 b[12] VGND 0.70619f
C2206 bitslice\[12\].u_fa/a_3048_156# VGND 0.00163f $ **FLOATING
C2207 bitslice\[12\].u_fa/a_1992_156# VGND 0.4914f $ **FLOATING
C2208 bitslice\[12\].u_fa/a_1072_156# VGND 0.29997f $ **FLOATING
C2209 bitslice\[12\].u_fa/a_680_156# VGND 0.00171f $ **FLOATING
C2210 bitslice\[12\].u_fa/a_512_156# VGND 0.00183f $ **FLOATING
C2211 bitslice\[12\].u_fa/a_3028_472# VGND 0 $ **FLOATING
C2212 bitslice\[12\].u_fa/a_2012_472# VGND 0.01495f $ **FLOATING
C2213 bitslice\[12\].u_fa/a_1072_496# VGND 0.0018f $ **FLOATING
C2214 bitslice\[12\].u_fa/a_952_112# VGND 0.56259f $ **FLOATING
C2215 bitslice\[12\].u_fa/a_124_46# VGND 0.48482f $ **FLOATING
C2216 bitslice\[7\].u_fa/CI VGND 0.92898f
C2217 a[6] VGND 1.96389f
C2218 s[6] VGND 0.26733f
C2219 b[6] VGND 0.70608f
C2220 bitslice\[6\].u_fa/a_3048_156# VGND 0.00163f $ **FLOATING
C2221 bitslice\[6\].u_fa/a_1992_156# VGND 0.4914f $ **FLOATING
C2222 bitslice\[6\].u_fa/a_1072_156# VGND 0.29997f $ **FLOATING
C2223 bitslice\[6\].u_fa/a_680_156# VGND 0.00171f $ **FLOATING
C2224 bitslice\[6\].u_fa/a_512_156# VGND 0.00183f $ **FLOATING
C2225 bitslice\[6\].u_fa/a_3028_472# VGND 0 $ **FLOATING
C2226 bitslice\[6\].u_fa/a_2012_472# VGND 0.01495f $ **FLOATING
C2227 bitslice\[6\].u_fa/a_1072_496# VGND 0.0018f $ **FLOATING
C2228 bitslice\[6\].u_fa/a_952_112# VGND 0.56259f $ **FLOATING
C2229 bitslice\[6\].u_fa/a_124_46# VGND 0.48482f $ **FLOATING
C2230 bitslice\[1\].u_fa/CI VGND 0.98163f
C2231 cin VGND 1.12714f
C2232 a[0] VGND 2.6551f
C2233 s[0] VGND 0.27209f
C2234 b[0] VGND 0.84146f
C2235 bitslice\[0\].u_fa/a_3048_156# VGND 0.00173f $ **FLOATING
C2236 bitslice\[0\].u_fa/a_1992_156# VGND 0.49098f $ **FLOATING
C2237 bitslice\[0\].u_fa/a_1072_156# VGND 0.29997f $ **FLOATING
C2238 bitslice\[0\].u_fa/a_680_156# VGND 0.00171f $ **FLOATING
C2239 bitslice\[0\].u_fa/a_512_156# VGND 0.00183f $ **FLOATING
C2240 bitslice\[0\].u_fa/a_3028_472# VGND 0 $ **FLOATING
C2241 bitslice\[0\].u_fa/a_2012_472# VGND 0.01495f $ **FLOATING
C2242 bitslice\[0\].u_fa/a_1072_496# VGND 0.0018f $ **FLOATING
C2243 bitslice\[0\].u_fa/a_952_112# VGND 0.56437f $ **FLOATING
C2244 bitslice\[0\].u_fa/a_124_46# VGND 0.48522f $ **FLOATING
C2245 bitslice\[18\].u_fa/CI VGND 1.13351f
C2246 a[17] VGND 1.89078f
C2247 s[17] VGND 0.31753f
C2248 b[17] VGND 0.70543f
C2249 bitslice\[17\].u_fa/a_3048_156# VGND 0.00172f $ **FLOATING
C2250 bitslice\[17\].u_fa/a_1992_156# VGND 0.4914f $ **FLOATING
C2251 bitslice\[17\].u_fa/a_1072_156# VGND 0.29997f $ **FLOATING
C2252 bitslice\[17\].u_fa/a_680_156# VGND 0.00171f $ **FLOATING
C2253 bitslice\[17\].u_fa/a_512_156# VGND 0.00183f $ **FLOATING
C2254 bitslice\[17\].u_fa/a_3028_472# VGND 0 $ **FLOATING
C2255 bitslice\[17\].u_fa/a_2012_472# VGND 0.01495f $ **FLOATING
C2256 bitslice\[17\].u_fa/a_1072_496# VGND 0.0018f $ **FLOATING
C2257 bitslice\[17\].u_fa/a_952_112# VGND 0.56133f $ **FLOATING
C2258 bitslice\[17\].u_fa/a_124_46# VGND 0.48482f $ **FLOATING
C2259 bitslice\[12\].u_fa/CI VGND 1.079f
C2260 a[11] VGND 1.89078f
C2261 s[11] VGND 0.31753f
C2262 b[11] VGND 0.70474f
C2263 bitslice\[11\].u_fa/a_3048_156# VGND 0.00172f $ **FLOATING
C2264 bitslice\[11\].u_fa/a_1992_156# VGND 0.4914f $ **FLOATING
C2265 bitslice\[11\].u_fa/a_1072_156# VGND 0.29997f $ **FLOATING
C2266 bitslice\[11\].u_fa/a_680_156# VGND 0.00171f $ **FLOATING
C2267 bitslice\[11\].u_fa/a_512_156# VGND 0.00183f $ **FLOATING
C2268 bitslice\[11\].u_fa/a_3028_472# VGND 0 $ **FLOATING
C2269 bitslice\[11\].u_fa/a_2012_472# VGND 0.01495f $ **FLOATING
C2270 bitslice\[11\].u_fa/a_1072_496# VGND 0.0018f $ **FLOATING
C2271 bitslice\[11\].u_fa/a_952_112# VGND 0.56133f $ **FLOATING
C2272 bitslice\[11\].u_fa/a_124_46# VGND 0.48482f $ **FLOATING
C2273 bitslice\[6\].u_fa/CI VGND 1.079f
C2274 a[5] VGND 1.89078f
C2275 s[5] VGND 0.31753f
C2276 b[5] VGND 0.70474f
C2277 bitslice\[5\].u_fa/a_3048_156# VGND 0.00172f $ **FLOATING
C2278 bitslice\[5\].u_fa/a_1992_156# VGND 0.4914f $ **FLOATING
C2279 bitslice\[5\].u_fa/a_1072_156# VGND 0.29997f $ **FLOATING
C2280 bitslice\[5\].u_fa/a_680_156# VGND 0.00171f $ **FLOATING
C2281 bitslice\[5\].u_fa/a_512_156# VGND 0.00183f $ **FLOATING
C2282 bitslice\[5\].u_fa/a_3028_472# VGND 0 $ **FLOATING
C2283 bitslice\[5\].u_fa/a_2012_472# VGND 0.01495f $ **FLOATING
C2284 bitslice\[5\].u_fa/a_1072_496# VGND 0.0018f $ **FLOATING
C2285 bitslice\[5\].u_fa/a_952_112# VGND 0.56133f $ **FLOATING
C2286 bitslice\[5\].u_fa/a_124_46# VGND 0.48482f $ **FLOATING
C2287 bitslice\[17\].u_fa/CI VGND 0.9311f
C2288 a[16] VGND 1.97081f
C2289 s[16] VGND 0.26733f
C2290 b[16] VGND 0.70619f
C2291 bitslice\[16\].u_fa/a_3048_156# VGND 0.00163f $ **FLOATING
C2292 bitslice\[16\].u_fa/a_1992_156# VGND 0.4914f $ **FLOATING
C2293 bitslice\[16\].u_fa/a_1072_156# VGND 0.29997f $ **FLOATING
C2294 bitslice\[16\].u_fa/a_680_156# VGND 0.00171f $ **FLOATING
C2295 bitslice\[16\].u_fa/a_512_156# VGND 0.00183f $ **FLOATING
C2296 bitslice\[16\].u_fa/a_3028_472# VGND 0 $ **FLOATING
C2297 bitslice\[16\].u_fa/a_2012_472# VGND 0.01495f $ **FLOATING
C2298 bitslice\[16\].u_fa/a_1072_496# VGND 0.0018f $ **FLOATING
C2299 bitslice\[16\].u_fa/a_952_112# VGND 0.56259f $ **FLOATING
C2300 bitslice\[16\].u_fa/a_124_46# VGND 0.48482f $ **FLOATING
C2301 bitslice\[11\].u_fa/CI VGND 0.92898f
C2302 a[10] VGND 1.96389f
C2303 s[10] VGND 0.26733f
C2304 b[10] VGND 0.70619f
C2305 bitslice\[10\].u_fa/a_3048_156# VGND 0.00163f $ **FLOATING
C2306 bitslice\[10\].u_fa/a_1992_156# VGND 0.4914f $ **FLOATING
C2307 bitslice\[10\].u_fa/a_1072_156# VGND 0.29997f $ **FLOATING
C2308 bitslice\[10\].u_fa/a_680_156# VGND 0.00171f $ **FLOATING
C2309 bitslice\[10\].u_fa/a_512_156# VGND 0.00183f $ **FLOATING
C2310 bitslice\[10\].u_fa/a_3028_472# VGND 0 $ **FLOATING
C2311 bitslice\[10\].u_fa/a_2012_472# VGND 0.01495f $ **FLOATING
C2312 bitslice\[10\].u_fa/a_1072_496# VGND 0.0018f $ **FLOATING
C2313 bitslice\[10\].u_fa/a_952_112# VGND 0.56259f $ **FLOATING
C2314 bitslice\[10\].u_fa/a_124_46# VGND 0.48482f $ **FLOATING
C2315 bitslice\[5\].u_fa/CI VGND 0.92637f
C2316 a[4] VGND 1.96379f
C2317 s[4] VGND 0.26733f
C2318 b[4] VGND 0.70619f
C2319 bitslice\[4\].u_fa/a_3048_156# VGND 0.00163f $ **FLOATING
C2320 bitslice\[4\].u_fa/a_1992_156# VGND 0.4914f $ **FLOATING
C2321 bitslice\[4\].u_fa/a_1072_156# VGND 0.29997f $ **FLOATING
C2322 bitslice\[4\].u_fa/a_680_156# VGND 0.00171f $ **FLOATING
C2323 bitslice\[4\].u_fa/a_512_156# VGND 0.00183f $ **FLOATING
C2324 bitslice\[4\].u_fa/a_3028_472# VGND 0 $ **FLOATING
C2325 bitslice\[4\].u_fa/a_2012_472# VGND 0.01495f $ **FLOATING
C2326 bitslice\[4\].u_fa/a_1072_496# VGND 0.0018f $ **FLOATING
C2327 bitslice\[4\].u_fa/a_952_112# VGND 0.56247f $ **FLOATING
C2328 bitslice\[4\].u_fa/a_124_46# VGND 0.48482f $ **FLOATING
C2329 bitslice\[16\].u_fa/CI VGND 1.079f
C2330 a[15] VGND 1.89078f
C2331 s[15] VGND 0.31753f
C2332 b[15] VGND 0.70474f
C2333 bitslice\[15\].u_fa/a_3048_156# VGND 0.00172f $ **FLOATING
C2334 bitslice\[15\].u_fa/a_1992_156# VGND 0.4914f $ **FLOATING
C2335 bitslice\[15\].u_fa/a_1072_156# VGND 0.29997f $ **FLOATING
C2336 bitslice\[15\].u_fa/a_680_156# VGND 0.00171f $ **FLOATING
C2337 bitslice\[15\].u_fa/a_512_156# VGND 0.00183f $ **FLOATING
C2338 bitslice\[15\].u_fa/a_3028_472# VGND 0 $ **FLOATING
C2339 bitslice\[15\].u_fa/a_2012_472# VGND 0.01495f $ **FLOATING
C2340 bitslice\[15\].u_fa/a_1072_496# VGND 0.0018f $ **FLOATING
C2341 bitslice\[15\].u_fa/a_952_112# VGND 0.56133f $ **FLOATING
C2342 bitslice\[15\].u_fa/a_124_46# VGND 0.48482f $ **FLOATING
C2343 bitslice\[9\].u_fa/CO VGND 1.08074f
C2344 a[9] VGND 1.89126f
C2345 s[9] VGND 0.33727f
C2346 b[9] VGND 0.70225f
C2347 bitslice\[9\].u_fa/a_3048_156# VGND 0.00172f $ **FLOATING
C2348 bitslice\[9\].u_fa/a_1992_156# VGND 0.4914f $ **FLOATING
C2349 bitslice\[9\].u_fa/a_1072_156# VGND 0.29997f $ **FLOATING
C2350 bitslice\[9\].u_fa/a_680_156# VGND 0.00171f $ **FLOATING
C2351 bitslice\[9\].u_fa/a_512_156# VGND 0.00183f $ **FLOATING
C2352 bitslice\[9\].u_fa/a_3028_472# VGND 0 $ **FLOATING
C2353 bitslice\[9\].u_fa/a_2012_472# VGND 0.01495f $ **FLOATING
C2354 bitslice\[9\].u_fa/a_1072_496# VGND 0.0018f $ **FLOATING
C2355 bitslice\[9\].u_fa/a_952_112# VGND 0.56215f $ **FLOATING
C2356 bitslice\[9\].u_fa/a_124_46# VGND 0.48482f $ **FLOATING
C2357 FILLER_21_2/a_484_472# VGND 0.37097f $ **FLOATING
C2358 FILLER_21_2/a_36_472# VGND 0.43137f $ **FLOATING
C2359 FILLER_21_2/a_572_375# VGND 0.20051f $ **FLOATING
C2360 FILLER_21_2/a_124_375# VGND 0.20507f $ **FLOATING
C2361 bitslice\[4\].u_fa/CI VGND 1.079f
C2362 a[3] VGND 1.89078f
C2363 s[3] VGND 0.31753f
C2364 b[3] VGND 0.70474f
C2365 bitslice\[3\].u_fa/a_3048_156# VGND 0.00172f $ **FLOATING
C2366 bitslice\[3\].u_fa/a_1992_156# VGND 0.4914f $ **FLOATING
C2367 bitslice\[3\].u_fa/a_1072_156# VGND 0.29997f $ **FLOATING
C2368 bitslice\[3\].u_fa/a_680_156# VGND 0.00171f $ **FLOATING
C2369 bitslice\[3\].u_fa/a_512_156# VGND 0.00183f $ **FLOATING
C2370 bitslice\[3\].u_fa/a_3028_472# VGND 0 $ **FLOATING
C2371 bitslice\[3\].u_fa/a_2012_472# VGND 0.01495f $ **FLOATING
C2372 bitslice\[3\].u_fa/a_1072_496# VGND 0.0018f $ **FLOATING
C2373 bitslice\[3\].u_fa/a_952_112# VGND 0.56133f $ **FLOATING
C2374 bitslice\[3\].u_fa/a_124_46# VGND 0.48482f $ **FLOATING
C2375 a[20] VGND 1.97289f
C2376 s[20] VGND 0.27192f
C2377 b[20] VGND 0.74652f
C2378 bitslice\[20\].u_fa/a_3048_156# VGND 0.00163f $ **FLOATING
C2379 bitslice\[20\].u_fa/a_1992_156# VGND 0.49086f $ **FLOATING
C2380 bitslice\[20\].u_fa/a_1072_156# VGND 0.29997f $ **FLOATING
C2381 bitslice\[20\].u_fa/a_680_156# VGND 0.00171f $ **FLOATING
C2382 bitslice\[20\].u_fa/a_512_156# VGND 0.00183f $ **FLOATING
C2383 bitslice\[20\].u_fa/a_3028_472# VGND 0 $ **FLOATING
C2384 bitslice\[20\].u_fa/a_2012_472# VGND 0.01276f $ **FLOATING
C2385 bitslice\[20\].u_fa/a_1072_496# VGND 0.0018f $ **FLOATING
C2386 bitslice\[20\].u_fa/a_952_112# VGND 0.56139f $ **FLOATING
C2387 bitslice\[20\].u_fa/a_124_46# VGND 0.48482f $ **FLOATING
C2388 bitslice\[15\].u_fa/CI VGND 0.93103f
C2389 a[14] VGND 1.96406f
C2390 s[14] VGND 0.26733f
C2391 b[14] VGND 0.70795f
C2392 bitslice\[14\].u_fa/a_3048_156# VGND 0.00173f $ **FLOATING
C2393 bitslice\[14\].u_fa/a_1992_156# VGND 0.4914f $ **FLOATING
C2394 bitslice\[14\].u_fa/a_1072_156# VGND 0.29997f $ **FLOATING
C2395 bitslice\[14\].u_fa/a_680_156# VGND 0.00171f $ **FLOATING
C2396 bitslice\[14\].u_fa/a_512_156# VGND 0.00183f $ **FLOATING
C2397 bitslice\[14\].u_fa/a_3028_472# VGND 0 $ **FLOATING
C2398 bitslice\[14\].u_fa/a_2012_472# VGND 0.01495f $ **FLOATING
C2399 bitslice\[14\].u_fa/a_1072_496# VGND 0.0018f $ **FLOATING
C2400 bitslice\[14\].u_fa/a_952_112# VGND 0.56323f $ **FLOATING
C2401 bitslice\[14\].u_fa/a_124_46# VGND 0.48482f $ **FLOATING
C2402 bitslice\[9\].u_fa/CI VGND 0.97226f
C2403 a[8] VGND 1.96363f
C2404 s[8] VGND 0.26733f
C2405 b[8] VGND 0.70587f
C2406 bitslice\[8\].u_fa/a_3048_156# VGND 0.00163f $ **FLOATING
C2407 bitslice\[8\].u_fa/a_1992_156# VGND 0.4914f $ **FLOATING
C2408 bitslice\[8\].u_fa/a_1072_156# VGND 0.29997f $ **FLOATING
C2409 bitslice\[8\].u_fa/a_680_156# VGND 0.00171f $ **FLOATING
C2410 bitslice\[8\].u_fa/a_512_156# VGND 0.00183f $ **FLOATING
C2411 bitslice\[8\].u_fa/a_3028_472# VGND 0 $ **FLOATING
C2412 bitslice\[8\].u_fa/a_2012_472# VGND 0.01495f $ **FLOATING
C2413 bitslice\[8\].u_fa/a_1072_496# VGND 0.0018f $ **FLOATING
C2414 bitslice\[8\].u_fa/a_952_112# VGND 0.5623f $ **FLOATING
C2415 bitslice\[8\].u_fa/a_124_46# VGND 0.48482f $ **FLOATING
C2416 s[21] VGND 0.83449f
C2417 b[21] VGND 0.8399f
C2418 a[21] VGND 0.84737f
C2419 u_msb_x3/A3 VGND 0.93749f
C2420 u_msb_x3/a_2215_68# VGND 0.00431f $ **FLOATING
C2421 u_msb_x3/a_952_93# VGND 0 $ **FLOATING
C2422 u_msb_x3/a_1936_472# VGND 0.00754f $ **FLOATING
C2423 u_msb_x3/a_1524_472# VGND 0 $ **FLOATING
C2424 u_msb_x3/a_718_524# VGND 0.00279f $ **FLOATING
C2425 u_msb_x3/a_244_524# VGND 0 $ **FLOATING
C2426 u_msb_x3/a_56_524# VGND 0.52567f $ **FLOATING
C2427 u_msb_x3/a_728_93# VGND 1.16559f $ **FLOATING
C2428 u_msb_x3/a_1336_472# VGND 0.56662f $ **FLOATING
C2429 bitslice\[3\].u_fa/CI VGND 0.92898f
C2430 a[2] VGND 1.96389f
C2431 s[2] VGND 0.26733f
C2432 b[2] VGND 0.70619f
C2433 bitslice\[2\].u_fa/a_3048_156# VGND 0.00163f $ **FLOATING
C2434 bitslice\[2\].u_fa/a_1992_156# VGND 0.4914f $ **FLOATING
C2435 bitslice\[2\].u_fa/a_1072_156# VGND 0.29997f $ **FLOATING
C2436 bitslice\[2\].u_fa/a_680_156# VGND 0.00171f $ **FLOATING
C2437 bitslice\[2\].u_fa/a_512_156# VGND 0.00183f $ **FLOATING
C2438 bitslice\[2\].u_fa/a_3028_472# VGND 0 $ **FLOATING
C2439 bitslice\[2\].u_fa/a_2012_472# VGND 0.01495f $ **FLOATING
C2440 bitslice\[2\].u_fa/a_1072_496# VGND 0.0018f $ **FLOATING
C2441 bitslice\[2\].u_fa/a_952_112# VGND 0.56259f $ **FLOATING
C2442 bitslice\[2\].u_fa/a_124_46# VGND 0.48482f $ **FLOATING
C2443 bitslice\[20\].u_fa/CI VGND 1.1119f
C2444 a[19] VGND 1.89078f
C2445 s[19] VGND 0.31753f
C2446 b[19] VGND 0.70474f
C2447 bitslice\[19\].u_fa/a_3048_156# VGND 0.00172f $ **FLOATING
C2448 bitslice\[19\].u_fa/a_1992_156# VGND 0.4914f $ **FLOATING
C2449 bitslice\[19\].u_fa/a_1072_156# VGND 0.29997f $ **FLOATING
C2450 bitslice\[19\].u_fa/a_680_156# VGND 0.00171f $ **FLOATING
C2451 bitslice\[19\].u_fa/a_512_156# VGND 0.00183f $ **FLOATING
C2452 bitslice\[19\].u_fa/a_3028_472# VGND 0 $ **FLOATING
C2453 bitslice\[19\].u_fa/a_2012_472# VGND 0.01495f $ **FLOATING
C2454 bitslice\[19\].u_fa/a_1072_496# VGND 0.0018f $ **FLOATING
C2455 bitslice\[19\].u_fa/a_952_112# VGND 0.56133f $ **FLOATING
C2456 bitslice\[19\].u_fa/a_124_46# VGND 0.48482f $ **FLOATING
C2457 bitslice\[14\].u_fa/CI VGND 1.10693f
C2458 a[13] VGND 1.89065f
C2459 s[13] VGND 0.31753f
C2460 b[13] VGND 0.70235f
C2461 bitslice\[13\].u_fa/a_3048_156# VGND 0.00172f $ **FLOATING
C2462 bitslice\[13\].u_fa/a_1992_156# VGND 0.4914f $ **FLOATING
C2463 bitslice\[13\].u_fa/a_1072_156# VGND 0.29997f $ **FLOATING
C2464 bitslice\[13\].u_fa/a_680_156# VGND 0.00171f $ **FLOATING
C2465 bitslice\[13\].u_fa/a_512_156# VGND 0.00183f $ **FLOATING
C2466 bitslice\[13\].u_fa/a_3028_472# VGND 0 $ **FLOATING
C2467 bitslice\[13\].u_fa/a_2012_472# VGND 0.01495f $ **FLOATING
C2468 bitslice\[13\].u_fa/a_1072_496# VGND 0.0018f $ **FLOATING
C2469 bitslice\[13\].u_fa/a_952_112# VGND 0.56169f $ **FLOATING
C2470 bitslice\[13\].u_fa/a_124_46# VGND 0.48482f $ **FLOATING
C2471 bitslice\[8\].u_fa/CI VGND 1.08207f
C2472 a[7] VGND 1.8845f
C2473 s[7] VGND 0.35441f
C2474 b[7] VGND 0.70474f
C2475 bitslice\[7\].u_fa/a_3048_156# VGND 0.00172f $ **FLOATING
C2476 bitslice\[7\].u_fa/a_1992_156# VGND 0.4914f $ **FLOATING
C2477 bitslice\[7\].u_fa/a_1072_156# VGND 0.29997f $ **FLOATING
C2478 bitslice\[7\].u_fa/a_680_156# VGND 0.00171f $ **FLOATING
C2479 bitslice\[7\].u_fa/a_512_156# VGND 0.00183f $ **FLOATING
C2480 bitslice\[7\].u_fa/a_3028_472# VGND 0 $ **FLOATING
C2481 bitslice\[7\].u_fa/a_2012_472# VGND 0.01495f $ **FLOATING
C2482 bitslice\[7\].u_fa/a_1072_496# VGND 0.0018f $ **FLOATING
C2483 bitslice\[7\].u_fa/a_952_112# VGND 0.56133f $ **FLOATING
C2484 bitslice\[7\].u_fa/a_124_46# VGND 0.48483f $ **FLOATING
.ends
